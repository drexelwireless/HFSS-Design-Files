# Ansys Electronics Desktop project, version 2018.0
materials:
  FR4_epoxy: permittivity=4.4 dielectric_loss_tangent=0.02
  air: permittivity=1.0006 permeability=1.0000004
  copper: permeability=0.999991 conductivity=58000000
  pec: conductivity=1e+30
  vacuum: permittivity=1

design DualBand_single elements_5GHz1 (HFSS, DrivenModal, model units mm)
options: Calculate_Lossy_Dielectrics
variables:
  h_substrate = 1.6mm
  top_width = 2.3mm
  top_length = 18.5mm
  width = 5
  length = 13mm
  width_branch = (3*1.5) mm
  wing_length = 8mm
  wing_width = (2*1.5) mm
  slot_length = (-5*1.5) mm
  radius = (5.5*1.5) mm
  topRadius = 1.5mm
  paras_width = 2mm
  paras_length = 22mm
  paras_distance = 7mm
geometry:
  Cylinder1 [pec] = cylinder(axis=Z, base_centre=(0mm, 0mm, 0mm), radius=0.5mm, height=-h_substrate)
  Cylinder1_1 = Cylinder1.copy()
  Cylinder1_2 = Cylinder1.copy()
  Cylinder2 [vacuum] = cylinder(axis=Z, base_centre=(0mm, 0mm, 0mm), radius=1.5mm, height=-h_substrate)
  Cylinder2.subtract(Cylinder1_1)
  Cylinder3 [pec] = cylinder(axis=Z, base_centre=(0mm, 0mm, -1.6mm), radius=1.6mm, height=-26.5mm)
  Circle3 = circle(normal=Z, centre=(0mm, 0mm, -1.6mm), radius=1.5mm)
  Circle3.subtract(Cylinder1_2)
  Box1 [FR4_epoxy] = box(corner=(0mm, 0mm, 0mm), size=(5mm, 5mm, -h_substrate))
  Box1.move_faces(MoveAlongNormalFlag=true OffsetDistance=50mm FacesToMove=Box1.face(-y))
  Box1.move_faces(MoveAlongNormalFlag=true OffsetDistance=45mm FacesToMove=Box1.face(+y))
  Box1.move_faces(MoveAlongNormalFlag=true OffsetDistance=45mm FacesToMove=Box1.face(+x))
  Box1.move_faces(MoveAlongNormalFlag=true OffsetDistance=50mm FacesToMove=Box1.face(-x))
  Box2 [air] = box(corner=(-1.5mm, -1.5mm, 0mm), size=(200mm, 200mm, 200mm))
  Box2.move_faces(MoveAlongNormalFlag=true OffsetDistance=200mm FacesToMove=Box2.face(-x))
  Box2.move_faces(MoveAlongNormalFlag=true OffsetDistance=200mm FacesToMove=Box2.face(-z))
  Box2.move_faces(MoveAlongNormalFlag=true OffsetDistance=200mm FacesToMove=Box2.face(-y))
  Box2.move_faces(MoveAlongNormalFlag=true OffsetDistance=-100mm FacesToMove=Box2.face(+z))
  Box2.move_faces(MoveAlongNormalFlag=true OffsetDistance=-100mm FacesToMove=Box2.face(+x))
  Box2.move_faces(MoveAlongNormalFlag=true OffsetDistance=-100mm FacesToMove=Box2.face(+y))
  Box2.move_faces(MoveAlongNormalFlag=true OffsetDistance=-100mm FacesToMove=Box2.face(-y))
  Box2.move_faces(MoveAlongNormalFlag=true OffsetDistance=-100mm FacesToMove=Box2.face(-x))
  Box2.move_faces(MoveAlongNormalFlag=true OffsetDistance=-100mm FacesToMove=Box2.face(-z))
  Signal1_1..Signal1_9 = imported_body(C:/Users/Damiano/AppData/Local/Temp/A58922814079319917..sm3)
  Signal2_1..Signal2_5 = imported_body(C:/Users/Damiano/AppData/Local/Temp/A8C9228140793200710..sm3)
  [Signal2_1..Signal2_5].move(0mm, 0mm, -1.6mm)
  Rectangle1 = rectangle(corner=(-2.25mm, -3.85mm, 0mm), x_size=4.5mm, y_size=0.7mm)
  Rectangle1.move(0mm, -11.15mm, 0mm)
  Rectangle1_1 = Rectangle1.duplicate_along_line(step=(0mm, 0mm, -1.6mm), total=2)
  Signal1_2.subtract(Rectangle1)
  Signal2_5.subtract(Rectangle1_1)
  Rectangle2 = rectangle(corner=(-2.25mm, -15mm, 0mm), x_size=4.5mm, y_size=0.7mm)
  Rectangle3 = rectangle(corner=(-2.25mm, -14.3mm, -1.6mm), x_size=4.5mm, y_size=-0.7mm)
  Rectangle3_1, Rectangle3_2, Rectangle3_3 = Rectangle3.duplicate_around_axis(axis=Z, angle=90deg, total=4)
  Rectangle3.delete()
  Rectangle2_1, Rectangle2_2, Rectangle2_3 = Rectangle2.duplicate_around_axis(axis=Z, angle=90deg, total=4)
  Rectangle2.delete()
  Signal1_5.subtract(Rectangle2_1)
  Signal2_3.subtract(Rectangle3_1)
  Signal1_3.subtract(Rectangle2_2)
  Signal2_4.subtract(Rectangle3_2)
  Signal1_1.subtract(Rectangle2_3)
  Signal2_1.subtract(Rectangle3_3)
  Signal1_10..Signal1_13 = imported_body(C:/Users/Damiano/AppData/Local/Temp/487C57641408538924100..sm3)
  [Signal1_10..Signal1_13].rotate(axis=Z, angle=45deg)
  Signal2_6..Signal2_9 = imported_body(C:/Users/Damiano/AppData/Local/Temp/49A857641408539016104..sm3)
  [Signal2_6..Signal2_9].rotate(axis=Z, angle=45deg)
  [Signal2_6..Signal2_9].move(0mm, 0mm, -1.6mm)
  Rectangle4 = rectangle(corner=(-2.25mm, -15mm, 0mm), x_size=4.5mm, y_size=0.7mm)
  Rectangle5 = rectangle(corner=(2.25mm, -15mm, -1.6mm), x_size=-4.5mm, y_size=0.7mm)
  Rectangle5_1, Rectangle5_2, Rectangle5_3 = Rectangle5.duplicate_around_axis(axis=Z, angle=90deg, total=4)
  Rectangle4_1, Rectangle4_2, Rectangle4_3 = Rectangle4.duplicate_around_axis(axis=Z, angle=90deg, total=4)
  Signal1_2.unite(Rectangle4)
  Signal1_1.unite(Rectangle4_3)
  Signal1_3.unite(Rectangle4_2)
  Signal1_5.unite(Rectangle4_1)
  Signal2_3.unite(Rectangle5_1)
  Signal2_5.unite(Rectangle5)
  Signal2_1.unite(Rectangle5_3)
  Signal2_4.unite(Rectangle5_2)
  Rectangle6 = rectangle(corner=(-2.25mm, -3.85mm, 0mm), x_size=4.5mm, y_size=0.5mm)
  Rectangle6_1, Rectangle6_2, Rectangle6_3 = Rectangle6.duplicate_around_axis(axis=Z, angle=90deg, total=4)
  Signal1_2.unite(Rectangle6)
  Signal1_1.unite(Rectangle6_3)
  Signal1_3.unite(Rectangle6_2)
  Signal1_5.unite(Rectangle6_1)
  coordinate_system RelativeCS1 = origin=(0mm, 0mm, 0mm) x=(-2.6056885mm, -2.6056885mm, 0mm) y=(-3mm, -2mm, 0mm)
  Rectangle7 = rectangle(corner=(4.235mm, -2.475mm, 0mm), x_size=-0.55mm, y_size=4.4mm) in RelativeCS1
  Rectangle8 = rectangle(corner=(4.235mm, 2.475mm, 0mm), x_size=-0.55mm, y_size=-0.55mm) in RelativeCS1
  Rectangle8.unite(Rectangle7)
  Rectangle8_1, Rectangle8_2, Rectangle8_3 = Rectangle8.duplicate_around_axis(axis=Z, angle=90deg, total=4) in RelativeCS1
  Signal1_11.unite(Rectangle8)
  Signal1_10.unite(Rectangle8_1)
  Signal1_12.unite(Rectangle8_2)
  Signal1_13.unite(Rectangle8_3)
  Polyline1 = polyline(z=0mm, xy in mm: (3.959798, -0.77781746) (5.959798, -2.7778175) (3.1643028, -1.5733126) (3.959798, -0.77781746), closed, covered) in RelativeCS1
  Polyline1_1, Polyline1_2, Polyline1_3 = Polyline1.duplicate_around_axis(axis=Z, angle=90deg, total=4) in RelativeCS1
  Polyline2 = polyline(z=0mm, xy in mm: (0.77781746, -3.959798) (2.7778175, -5.959798) (1.5733126, -3.1643028) (0.77781746, -3.959798), closed, covered) in RelativeCS1
  Polyline2_1, Polyline2_2, Polyline2_3 = Polyline2.duplicate_around_axis(axis=Z, angle=90deg, total=4) in RelativeCS1
  Signal1_2.subtract(Polyline1, Polyline2)
  Signal1_1.subtract(Polyline1_1, Polyline2_1)
  Signal1_3.subtract(Polyline1_2, Polyline2_2)
  Signal1_5.subtract(Polyline1_3, Polyline2_3)
  Polyline3 = polyline(z=0mm, xy in mm: (3.685, -2.475) (5.885, -2.475) (3.685, -1.475) (3.685, -2.475), closed, covered) in RelativeCS1
  Polyline3_1 = Polyline3.duplicate_around_axis(axis=X, angle=180deg, total=2) in RelativeCS1
  Polyline3_2, Polyline3_3, Polyline3_4 = Polyline3.duplicate_around_axis(axis=Z, angle=90deg, total=4) in RelativeCS1
  Polyline3_1_1, Polyline3_1_2, Polyline3_1_3 = Polyline3_1.duplicate_around_axis(axis=Z, angle=90deg, total=4) in RelativeCS1
  Signal1_11.subtract(Polyline3, Polyline3_1)
  Signal1_10.subtract(Polyline3_1_1, Polyline3_2)
  Signal1_12.subtract(Polyline3_1_2, Polyline3_3)
  Signal1_13.subtract(Polyline3_1_3, Polyline3_4)
  Rectangle9 = rectangle(corner=(3.685mm, -1.475mm, 0mm), x_size=-2.3314463mm, y_size=0.82855308mm) in RelativeCS1
  Rectangle9.move(-2.220446e-15mm, 1.0607235mm, 0mm) in RelativeCS1
  Rectangle9_1 = Rectangle9.duplicate_around_axis(axis=Z, angle=90deg, total=4) in RelativeCS1  # copies kept: 1
  Rectangle9.delete()
  Rectangle10 = rectangle(corner=(9.940979mm, -1.925mm, 1.6mm), x_size=-1.9109506mm, y_size=0.8mm) in RelativeCS1
  Rectangle10.move(-3.5527137e-15mm, 1.525mm, -2.220446e-16mm) in RelativeCS1
  Rectangle10_1 = Rectangle10.duplicate_around_axis(axis=Z, angle=90deg, total=4) in RelativeCS1  # copies kept: 1
  Rectangle10.delete()
  Rectangle11 = rectangle(corner=(-14.3mm, 6.775mm, 0mm), x_size=-1mm, y_size=-12mm) in RelativeCS1
  Rectangle11.move(1.7763568e-15mm, -0.525mm, 0mm) in RelativeCS1
  Rectangle11.move(7.1054274e-15mm, 6.525mm, 0mm) in RelativeCS1
  Rectangle11.move(-1mm, -6.525mm, 0mm) in RelativeCS1
  Rectangle11_1, Rectangle11_2, Rectangle11_3 = Rectangle11.duplicate_around_axis(axis=Z, angle=90deg, total=4) in RelativeCS1
  Rectangle12 = rectangle(corner=(-15.3mm, -5.75mm, 0mm), x_size=-1mm, y_size=1.5mm) in RelativeCS1
  Rectangle12_1 = Rectangle12.duplicate_along_line(step=(8.8817842e-15mm, 10.5mm, 0mm), total=2) in RelativeCS1
  Rectangle12_2, Rectangle12_3, Rectangle12_4 = Rectangle12.duplicate_around_axis(axis=Z, angle=90deg, total=4) in RelativeCS1
  Rectangle12_1_1, Rectangle12_1_2, Rectangle12_1_3 = Rectangle12_1.duplicate_around_axis(axis=Z, angle=90deg, total=4) in RelativeCS1
  Rectangle11.subtract(Rectangle12, Rectangle12_1)
  Rectangle11_3.subtract(Rectangle12_1_3, Rectangle12_4)
  Rectangle11_2.subtract(Rectangle12_1_2, Rectangle12_3)
  Rectangle11_1.subtract(Rectangle12_1_1, Rectangle12_2)
  Rectangle13 = rectangle(corner=(13.2mm, 6.775mm, 1.6mm), x_size=1.1mm, y_size=1.5mm) in RelativeCS1
  Rectangle13_1 = Rectangle13.duplicate_along_line(step=(-8.8817842e-15mm, -15.05mm, -1.6mm), total=2) in RelativeCS1
  Rectangle13_2, Rectangle13_3, Rectangle13_4 = Rectangle13.duplicate_around_axis(axis=Z, angle=90deg, total=4) in RelativeCS1
  Rectangle13_1_1, Rectangle13_1_2, Rectangle13_1_3 = Rectangle13_1.duplicate_around_axis(axis=Z, angle=90deg, total=4) in RelativeCS1
  Signal2_6.unite(Rectangle13)
  Signal1_11.unite(Rectangle13_1)
  Signal1_10.unite(Rectangle13_1_1)
  Signal2_8.unite(Rectangle13_2)
  Signal1_12.unite(Rectangle13_1_2)
  Signal2_7.unite(Rectangle13_3)
  Signal2_9.unite(Rectangle13_4)
  Signal1_13.unite(Rectangle13_1_3)
  Rectangle9_1_1 = Rectangle9_1.duplicate_around_axis(axis=Z, angle=45deg, total=2) in RelativeCS1
  Rectangle10_1_1 = Rectangle10_1.duplicate_around_axis(axis=Z, angle=45deg, total=2) in RelativeCS1
boundaries and excitations:
  Rad1: Radiation Objects=Box2
  copper: Perfect E Objects=[Signal1_1..Signal1_9, Signal2_1..Signal2_5]
  5GHz: Perfect E Objects=[Signal1_10..Signal1_13, Signal2_6..Signal2_9]
  parasitics_5GHz: Perfect E Objects=[Rectangle11, Rectangle11_1, Rectangle11_2, Rectangle11_3]
  short: Perfect E Objects=[Rectangle9_1, Rectangle9_1_1, Rectangle10_1, Rectangle10_1_1]
  1: Wave Port Objects=Circle3 NumModes=1 Modes{Mode1{IntLine{Circle3.vertex(#15507) -> Circle3.vertex(1 of 1)} CharImp=Zpi}}
setups:
  Setup1: HfssDriven Frequency=6GHz MaxDeltaS=0.02 MaximumPasses=12 MinimumPasses=1 MinimumConvergedPasses=1 PercentRefinement=30 BasisOrder=-1 PortAccuracy=2 IterativeResidual=0.0001 DDMSolverResidual=0.0001
    sweep Sweep: 2GHz to 6GHz step 0.1GHz; Type=Fast SaveFields
source amplitudes:
  1:1: 1 0deg
radiation setups:
  Infinite Sphere1: Infinite Sphere Theta=-180deg..180deg step 10deg Phi=0deg..360deg step 10deg
field plots:
  Mag_Jsurf1: Jsurf over Signal2_4.face(at (0, 11.6686, -1.6)) Signal1_3.face(at (-8.4, 21.5, 0)) on Setup1 : Sweep at Freq=2GHz Phase=0deg
reports:
  XY Plot 1: dB(S(1,1)) vs Freq on Setup1 : Sweep; markers m1 at 4.9GHz, m2 at 3.3GHz
  3D Polar Plot 1: dB(GainTotal) vs Phi, Theta on Setup1 : Sweep, Infinite Sphere1 [Freq=5.5GHz]
  Gain Plot 1: dB(GainTotal) vs Phi, Theta on Setup1 : Sweep, Infinite Sphere1 [Freq=2.4GHz]
  S Parameter Chart 1: S(1,1) on Setup1 : Sweep [Freq=all]; markers m1 at 2.4GHz, m2 at 5GHz

design DualBand_all elements_Omni3_5GHz2 (HFSS, DrivenModal, model units mm)
options: Calculate_Lossy_Dielectrics
variables:
  h_substrate = 1.6mm
  top_width = 2.3mm
  top_length = 18.5mm
  width = 5
  length = 13mm
  width_branch = (3*1.5) mm
  wing_length = 8mm
  wing_width = (2*1.5) mm
  slot_length = (-5*1.5) mm
  radius = (5.5*1.5) mm
  topRadius = 1.5mm
  paras_width = 2mm
  paras_length = 22mm
  paras_distance = 7mm
geometry:
  Cylinder1 [pec] = cylinder(axis=Z, base_centre=(0mm, 0mm, 0mm), radius=0.5mm, height=-h_substrate)
  Cylinder1_1 = Cylinder1.copy()
  Cylinder1_2 = Cylinder1.copy()
  Cylinder2 [vacuum] = cylinder(axis=Z, base_centre=(0mm, 0mm, 0mm), radius=1.5mm, height=-h_substrate)
  Cylinder2.subtract(Cylinder1_1)
  Cylinder3 [pec] = cylinder(axis=Z, base_centre=(0mm, 0mm, -1.6mm), radius=1.6mm, height=-26.5mm)
  Circle3 = circle(normal=Z, centre=(0mm, 0mm, -1.6mm), radius=1.5mm)
  Circle3.subtract(Cylinder1_2)
  Box1 [FR4_epoxy] = box(corner=(0mm, 0mm, 0mm), size=(5mm, 5mm, -h_substrate))
  Box1.move_faces(MoveAlongNormalFlag=true OffsetDistance=50mm FacesToMove=Box1.face(-y))
  Box1.move_faces(MoveAlongNormalFlag=true OffsetDistance=45mm FacesToMove=Box1.face(+y))
  Box1.move_faces(MoveAlongNormalFlag=true OffsetDistance=45mm FacesToMove=Box1.face(+x))
  Box1.move_faces(MoveAlongNormalFlag=true OffsetDistance=50mm FacesToMove=Box1.face(-x))
  Box2 [air] = box(corner=(-1.5mm, -1.5mm, 0mm), size=(200mm, 200mm, 200mm))
  Box2.move_faces(MoveAlongNormalFlag=true OffsetDistance=200mm FacesToMove=Box2.face(-x))
  Box2.move_faces(MoveAlongNormalFlag=true OffsetDistance=200mm FacesToMove=Box2.face(-z))
  Box2.move_faces(MoveAlongNormalFlag=true OffsetDistance=200mm FacesToMove=Box2.face(-y))
  Box2.move_faces(MoveAlongNormalFlag=true OffsetDistance=-100mm FacesToMove=Box2.face(+z))
  Box2.move_faces(MoveAlongNormalFlag=true OffsetDistance=-100mm FacesToMove=Box2.face(+x))
  Box2.move_faces(MoveAlongNormalFlag=true OffsetDistance=-100mm FacesToMove=Box2.face(+y))
  Box2.move_faces(MoveAlongNormalFlag=true OffsetDistance=-100mm FacesToMove=Box2.face(-y))
  Box2.move_faces(MoveAlongNormalFlag=true OffsetDistance=-100mm FacesToMove=Box2.face(-x))
  Box2.move_faces(MoveAlongNormalFlag=true OffsetDistance=-100mm FacesToMove=Box2.face(-z))
  Signal1_1..Signal1_9 = imported_body(C:/Users/Damiano/AppData/Local/Temp/A58922814079319917..sm3)
  Signal2_1..Signal2_5 = imported_body(C:/Users/Damiano/AppData/Local/Temp/A8C9228140793200710..sm3)
  [Signal2_1..Signal2_5].move(0mm, 0mm, -1.6mm)
  Rectangle1 = rectangle(corner=(-2.25mm, -3.85mm, 0mm), x_size=4.5mm, y_size=0.7mm)
  Rectangle1.move(0mm, -11.15mm, 0mm)
  Rectangle1_1 = Rectangle1.duplicate_along_line(step=(0mm, 0mm, -1.6mm), total=2)
  Signal1_2.subtract(Rectangle1)
  Signal2_5.subtract(Rectangle1_1)
  Rectangle2 = rectangle(corner=(-2.25mm, -15mm, 0mm), x_size=4.5mm, y_size=0.7mm)
  Rectangle3 = rectangle(corner=(-2.25mm, -14.3mm, -1.6mm), x_size=4.5mm, y_size=-0.7mm)
  Rectangle3_1, Rectangle3_2, Rectangle3_3 = Rectangle3.duplicate_around_axis(axis=Z, angle=90deg, total=4)
  Rectangle3.delete()
  Rectangle2_1, Rectangle2_2, Rectangle2_3 = Rectangle2.duplicate_around_axis(axis=Z, angle=90deg, total=4)
  Rectangle2.delete()
  Signal1_5.subtract(Rectangle2_1)
  Signal2_3.subtract(Rectangle3_1)
  Signal1_3.subtract(Rectangle2_2)
  Signal2_4.subtract(Rectangle3_2)
  Signal1_1.subtract(Rectangle2_3)
  Signal2_1.subtract(Rectangle3_3)
  Signal1_10..Signal1_13 = imported_body(C:/Users/Damiano/AppData/Local/Temp/487C57641408538924100..sm3)
  [Signal1_10..Signal1_13].rotate(axis=Z, angle=45deg)
  Signal2_6..Signal2_9 = imported_body(C:/Users/Damiano/AppData/Local/Temp/49A857641408539016104..sm3)
  [Signal2_6..Signal2_9].rotate(axis=Z, angle=45deg)
  [Signal2_6..Signal2_9].move(0mm, 0mm, -1.6mm)
  Rectangle4 = rectangle(corner=(-2.25mm, -15mm, 0mm), x_size=4.5mm, y_size=0.7mm)
  Rectangle5 = rectangle(corner=(2.25mm, -15mm, -1.6mm), x_size=-4.5mm, y_size=0.7mm)
  Rectangle5_1, Rectangle5_2, Rectangle5_3 = Rectangle5.duplicate_around_axis(axis=Z, angle=90deg, total=4)
  Rectangle4_1, Rectangle4_2, Rectangle4_3 = Rectangle4.duplicate_around_axis(axis=Z, angle=90deg, total=4)
  Signal1_2.unite(Rectangle4)
  Signal1_1.unite(Rectangle4_3)
  Signal1_3.unite(Rectangle4_2)
  Signal1_5.unite(Rectangle4_1)
  Signal2_3.unite(Rectangle5_1)
  Signal2_5.unite(Rectangle5)
  Signal2_1.unite(Rectangle5_3)
  Signal2_4.unite(Rectangle5_2)
  Rectangle6 = rectangle(corner=(-2.25mm, -3.85mm, 0mm), x_size=4.5mm, y_size=0.5mm)
  Rectangle6_1, Rectangle6_2, Rectangle6_3 = Rectangle6.duplicate_around_axis(axis=Z, angle=90deg, total=4)
  Signal1_2.unite(Rectangle6)
  Signal1_1.unite(Rectangle6_3)
  Signal1_3.unite(Rectangle6_2)
  Signal1_5.unite(Rectangle6_1)
  coordinate_system RelativeCS1 = origin=(0mm, 0mm, 0mm) x=(-2.6056885mm, -2.6056885mm, 0mm) y=(-3mm, -2mm, 0mm)
  Rectangle7 = rectangle(corner=(4.235mm, -2.475mm, 0mm), x_size=-0.55mm, y_size=4.4mm) in RelativeCS1
  Rectangle8 = rectangle(corner=(4.235mm, 2.475mm, 0mm), x_size=-0.55mm, y_size=-0.55mm) in RelativeCS1
  Rectangle8.unite(Rectangle7)
  Rectangle8_1, Rectangle8_2, Rectangle8_3 = Rectangle8.duplicate_around_axis(axis=Z, angle=90deg, total=4) in RelativeCS1
  Signal1_11.unite(Rectangle8)
  Signal1_10.unite(Rectangle8_1)
  Signal1_12.unite(Rectangle8_2)
  Signal1_13.unite(Rectangle8_3)
  Polyline1 = polyline(z=0mm, xy in mm: (3.959798, -0.77781746) (5.959798, -2.7778175) (3.1643028, -1.5733126) (3.959798, -0.77781746), closed, covered) in RelativeCS1
  Polyline1_1, Polyline1_2, Polyline1_3 = Polyline1.duplicate_around_axis(axis=Z, angle=90deg, total=4) in RelativeCS1
  Polyline2 = polyline(z=0mm, xy in mm: (0.77781746, -3.959798) (2.7778175, -5.959798) (1.5733126, -3.1643028) (0.77781746, -3.959798), closed, covered) in RelativeCS1
  Polyline2_1, Polyline2_2, Polyline2_3 = Polyline2.duplicate_around_axis(axis=Z, angle=90deg, total=4) in RelativeCS1
  Signal1_2.subtract(Polyline1, Polyline2)
  Signal1_1.subtract(Polyline1_1, Polyline2_1)
  Signal1_3.subtract(Polyline1_2, Polyline2_2)
  Signal1_5.subtract(Polyline1_3, Polyline2_3)
  Polyline3 = polyline(z=0mm, xy in mm: (3.685, -2.475) (5.885, -2.475) (3.685, -1.475) (3.685, -2.475), closed, covered) in RelativeCS1
  Polyline3_1 = Polyline3.duplicate_around_axis(axis=X, angle=180deg, total=2) in RelativeCS1
  Polyline3_2, Polyline3_3, Polyline3_4 = Polyline3.duplicate_around_axis(axis=Z, angle=90deg, total=4) in RelativeCS1
  Polyline3_1_1, Polyline3_1_2, Polyline3_1_3 = Polyline3_1.duplicate_around_axis(axis=Z, angle=90deg, total=4) in RelativeCS1
  Signal1_11.subtract(Polyline3, Polyline3_1)
  Signal1_10.subtract(Polyline3_1_1, Polyline3_2)
  Signal1_12.subtract(Polyline3_1_2, Polyline3_3)
  Signal1_13.subtract(Polyline3_1_3, Polyline3_4)
  Rectangle9 = rectangle(corner=(3.685mm, -1.475mm, 0mm), x_size=-2.3314463mm, y_size=0.82855308mm) in RelativeCS1
  Rectangle9.move(-2.220446e-15mm, 1.0607235mm, 0mm) in RelativeCS1
  Rectangle9_1 = Rectangle9.duplicate_around_axis(axis=Z, angle=90deg, total=4) in RelativeCS1  # copies kept: 1
  Rectangle9.delete()
  Rectangle10 = rectangle(corner=(9.940979mm, -1.925mm, 1.6mm), x_size=-1.9109506mm, y_size=0.8mm) in RelativeCS1
  Rectangle10.move(-3.5527137e-15mm, 1.525mm, -2.220446e-16mm) in RelativeCS1
  Rectangle10_1 = Rectangle10.duplicate_around_axis(axis=Z, angle=90deg, total=4) in RelativeCS1  # copies kept: 1
  Rectangle10.delete()
  Rectangle11 = rectangle(corner=(-14.3mm, 6.775mm, 0mm), x_size=-1mm, y_size=-12mm) in RelativeCS1
  Rectangle11.move(1.7763568e-15mm, -0.525mm, 0mm) in RelativeCS1
  Rectangle11.move(7.1054274e-15mm, 6.525mm, 0mm) in RelativeCS1
  Rectangle11.move(-1mm, -6.525mm, 0mm) in RelativeCS1
  Rectangle11_1, Rectangle11_2, Rectangle11_3 = Rectangle11.duplicate_around_axis(axis=Z, angle=90deg, total=4) in RelativeCS1
  Rectangle12 = rectangle(corner=(-15.3mm, -5.75mm, 0mm), x_size=-1mm, y_size=1.5mm) in RelativeCS1
  Rectangle12_1 = Rectangle12.duplicate_along_line(step=(8.8817842e-15mm, 10.5mm, 0mm), total=2) in RelativeCS1
  Rectangle12_2, Rectangle12_3, Rectangle12_4 = Rectangle12.duplicate_around_axis(axis=Z, angle=90deg, total=4) in RelativeCS1
  Rectangle12_1_1, Rectangle12_1_2, Rectangle12_1_3 = Rectangle12_1.duplicate_around_axis(axis=Z, angle=90deg, total=4) in RelativeCS1
  Rectangle11.subtract(Rectangle12, Rectangle12_1)
  Rectangle11_3.subtract(Rectangle12_1_3, Rectangle12_4)
  Rectangle11_2.subtract(Rectangle12_1_2, Rectangle12_3)
  Rectangle11_1.subtract(Rectangle12_1_1, Rectangle12_2)
  Rectangle13 = rectangle(corner=(13.2mm, 6.775mm, 1.6mm), x_size=1.1mm, y_size=1.5mm) in RelativeCS1
  Rectangle13_1 = Rectangle13.duplicate_along_line(step=(-8.8817842e-15mm, -15.05mm, -1.6mm), total=2) in RelativeCS1
  Rectangle13_2, Rectangle13_3, Rectangle13_4 = Rectangle13.duplicate_around_axis(axis=Z, angle=90deg, total=4) in RelativeCS1
  Rectangle13_1_1, Rectangle13_1_2, Rectangle13_1_3 = Rectangle13_1.duplicate_around_axis(axis=Z, angle=90deg, total=4) in RelativeCS1
  Signal2_6.unite(Rectangle13)
  Signal1_11.unite(Rectangle13_1)
  Signal1_10.unite(Rectangle13_1_1)
  Signal2_8.unite(Rectangle13_2)
  Signal1_12.unite(Rectangle13_1_2)
  Signal2_7.unite(Rectangle13_3)
  Signal2_9.unite(Rectangle13_4)
  Signal1_13.unite(Rectangle13_1_3)
  Rectangle9_1_1 = Rectangle9_1.duplicate_around_axis(axis=Z, angle=45deg, total=2) in RelativeCS1
  Rectangle10_1_1 = Rectangle10_1.duplicate_around_axis(axis=Z, angle=45deg, total=2) in RelativeCS1
  Rectangle9_1_2, Rectangle9_1_3, Rectangle9_1_4 = Rectangle9_1.duplicate_around_axis(axis=Z, angle=90deg, total=4) in RelativeCS1
  Rectangle9_1_1_1, Rectangle9_1_1_2, Rectangle9_1_1_3 = Rectangle9_1_1.duplicate_around_axis(axis=Z, angle=90deg, total=4) in RelativeCS1
  Rectangle10_1_2, Rectangle10_1_3, Rectangle10_1_4 = Rectangle10_1.duplicate_around_axis(axis=Z, angle=90deg, total=4) in RelativeCS1
  Rectangle10_1_4_1, Rectangle10_1_4_2, Rectangle10_1_4_3 = Rectangle10_1_4.duplicate_around_axis(axis=Z, angle=90deg, total=4) in RelativeCS1
  Rectangle10_1_1_1, Rectangle10_1_1_2, Rectangle10_1_1_3 = Rectangle10_1_1.duplicate_around_axis(axis=Z, angle=90deg, total=4) in RelativeCS1
boundaries and excitations:
  Rad1: Radiation Objects=Box2
  copper: Perfect E Objects=[Signal1_1..Signal1_9, Signal2_1..Signal2_5]
  5GHz: Perfect E Objects=[Signal1_10..Signal1_13, Signal2_6..Signal2_9]
  parasitics_5GHz: Perfect E Objects=[Rectangle11, Rectangle11_1, Rectangle11_2, Rectangle11_3]
  short: Perfect E Objects=[Rectangle9_1, Rectangle9_1_1, Rectangle9_1_1_1, Rectangle9_1_1_2, Rectangle9_1_1_3, Rectangle9_1_2, Rectangle9_1_3, Rectangle9_1_4, Rectangle10_1, Rectangle10_1_1, Rectangle10_1_1_1, Rectangle10_1_1_2, Rectangle10_1_1_3, Rectangle10_1_2, Rectangle10_1_3, Rectangle10_1_4, Rectangle10_1_4_1, Rectangle10_1_4_2, Rectangle10_1_4_3]
  1: Wave Port Objects=Circle3 NumModes=1 Modes{Mode1{IntLine{Circle3.vertex(#15507) -> Circle3.vertex(1 of 1)} CharImp=Zpi}}
setups:
  Setup1: HfssDriven Frequency=6GHz MaxDeltaS=0.02 MaximumPasses=12 MinimumPasses=1 MinimumConvergedPasses=1 PercentRefinement=30 BasisOrder=-1 PortAccuracy=2 IterativeResidual=0.0001 DDMSolverResidual=0.0001
    sweep Sweep: 2GHz to 6GHz step 0.1GHz; Type=Fast SaveFields
source amplitudes:
  1:1: 1 0deg
radiation setups:
  Infinite Sphere1: Infinite Sphere Theta=-180deg..180deg step 10deg Phi=0deg..360deg step 10deg
reports:
  XY Plot 1: dB(S(1,1)) vs Freq on Setup1 : Sweep; markers m1 at 4.9GHz, m2 at 3.3GHz
  3D Polar Plot 1: dB(GainTotal) vs Phi, Theta on Setup1 : Sweep, Infinite Sphere1 [Freq=2.4GHz]
  Gain Plot 1: dB(GainTotal) vs Phi, Theta on Setup1 : Sweep, Infinite Sphere1 [Freq=2.4GHz]
  S Parameter Chart 1: S(1,1) on Setup1 : Sweep [Freq=all]; markers m1 at 2.4GHz, m2 at 5GHz
  S Parameter Chart 2: S(1,1) on Setup1 : Sweep [Freq=all]
