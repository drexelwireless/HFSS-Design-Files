# Ansys Electronics Desktop project, version 2018.1
materials:
  vacuum: permittivity=1
  Rogers RT/duroid 5880 (tm): permittivity=2.2 dielectric_loss_tangent=0.0009
  Rogers RO4003 (tm): permittivity=3.55 dielectric_loss_tangent=0.0027
  polyethylene: permittivity=2.25 dielectric_loss_tangent=0.001
  Teflon (tm): permittivity=2.1 dielectric_loss_tangent=0.001
  brass: conductivity=15000000
  copper: permeability=0.999991 conductivity=58000000
  pec: conductivity=1e+30
  PMLGroup1_Z_1: permittivity{anisotropic component1=1.1 component2=1.1 component3=0.45454545} permeability{anisotropic component1=1.1 component2=1.1 component3=0.45454545} dielectric_loss_tangent{anisotropic component1=1 component2=1 component3=-1} magnetic_loss_tangent{anisotropic component1=1 component2=1 component3=-1}
  PMLGroup1_XZ_1: permittivity{anisotropic component1=1 component2=0.01 component3=1} permeability{anisotropic component1=1 component2=0.01 component3=1} dielectric_loss_tangent{anisotropic component1=0 component2=242 component3=0} magnetic_loss_tangent{anisotropic component1=0 component2=242 component3=0}
  PMLGroup1_YZ_1: permittivity{anisotropic component1=0.01 component2=1 component3=1} permeability{anisotropic component1=0.01 component2=1 component3=1} dielectric_loss_tangent{anisotropic component1=242 component2=0 component3=0} magnetic_loss_tangent{anisotropic component1=242 component2=0 component3=0}
  PMLGroup1_XYZ_1: permittivity{anisotropic component1=1.1 component2=1.1 component3=1.1} permeability{anisotropic component1=1.1 component2=1.1 component3=1.1} dielectric_loss_tangent{anisotropic component1=1 component2=1 component3=1} magnetic_loss_tangent{anisotropic component1=1 component2=1 component3=1}
  PMLGroup1_Z_2: permittivity{anisotropic component1=1.1 component2=1.1 component3=0.45454545} permeability{anisotropic component1=1.1 component2=1.1 component3=0.45454545} dielectric_loss_tangent{anisotropic component1=1 component2=1 component3=-1} magnetic_loss_tangent{anisotropic component1=1 component2=1 component3=-1}
  PMLGroup1_XZ_2: permittivity{anisotropic component1=1 component2=0.01 component3=1} permeability{anisotropic component1=1 component2=0.01 component3=1} dielectric_loss_tangent{anisotropic component1=0 component2=242 component3=0} magnetic_loss_tangent{anisotropic component1=0 component2=242 component3=0}
  PMLGroup1_YZ_2: permittivity{anisotropic component1=0.01 component2=1 component3=1} permeability{anisotropic component1=0.01 component2=1 component3=1} dielectric_loss_tangent{anisotropic component1=242 component2=0 component3=0} magnetic_loss_tangent{anisotropic component1=242 component2=0 component3=0}
  PMLGroup1_XYZ_2: permittivity{anisotropic component1=1.1 component2=1.1 component3=1.1} permeability{anisotropic component1=1.1 component2=1.1 component3=1.1} dielectric_loss_tangent{anisotropic component1=1 component2=1 component3=1} magnetic_loss_tangent{anisotropic component1=1 component2=1 component3=1}
  Rogers RT/duroid 5880 (tm)1: permittivity=2.3 dielectric_loss_tangent=0.0009
  PMLGroup1_Z_3: permittivity{anisotropic component1=1.1 component2=1.1 component3=0.45454545} permeability{anisotropic component1=1.1 component2=1.1 component3=0.45454545} dielectric_loss_tangent{anisotropic component1=1 component2=1 component3=-1} magnetic_loss_tangent{anisotropic component1=1 component2=1 component3=-1}
  PMLGroup1_XZ_3: permittivity{anisotropic component1=1 component2=0.01 component3=1} permeability{anisotropic component1=1 component2=0.01 component3=1} dielectric_loss_tangent{anisotropic component1=0 component2=242 component3=0} magnetic_loss_tangent{anisotropic component1=0 component2=242 component3=0}
  PMLGroup1_YZ_3: permittivity{anisotropic component1=0.01 component2=1 component3=1} permeability{anisotropic component1=0.01 component2=1 component3=1} dielectric_loss_tangent{anisotropic component1=242 component2=0 component3=0} magnetic_loss_tangent{anisotropic component1=242 component2=0 component3=0}
  PMLGroup1_XYZ_3: permittivity{anisotropic component1=1.1 component2=1.1 component3=1.1} permeability{anisotropic component1=1.1 component2=1.1 component3=1.1} dielectric_loss_tangent{anisotropic component1=1 component2=1 component3=1} magnetic_loss_tangent{anisotropic component1=1 component2=1 component3=1}
  polyester: permittivity=3.2 dielectric_loss_tangent=0.003
  PMLGroup1_Z_4: permittivity{anisotropic component1=1.1 component2=1.1 component3=0.45454545} permeability{anisotropic component1=1.1 component2=1.1 component3=0.45454545} dielectric_loss_tangent{anisotropic component1=1 component2=1 component3=-1} magnetic_loss_tangent{anisotropic component1=1 component2=1 component3=-1}
  PMLGroup1_XZ_4: permittivity{anisotropic component1=1 component2=0.01 component3=1} permeability{anisotropic component1=1 component2=0.01 component3=1} dielectric_loss_tangent{anisotropic component1=0 component2=242 component3=0} magnetic_loss_tangent{anisotropic component1=0 component2=242 component3=0}
  PMLGroup1_YZ_4: permittivity{anisotropic component1=0.01 component2=1 component3=1} permeability{anisotropic component1=0.01 component2=1 component3=1} dielectric_loss_tangent{anisotropic component1=242 component2=0 component3=0} magnetic_loss_tangent{anisotropic component1=242 component2=0 component3=0}
  PMLGroup1_XYZ_4: permittivity{anisotropic component1=1.1 component2=1.1 component3=1.1} permeability{anisotropic component1=1.1 component2=1.1 component3=1.1} dielectric_loss_tangent{anisotropic component1=1 component2=1 component3=1} magnetic_loss_tangent{anisotropic component1=1 component2=1 component3=1}
  PMLGroup1_Z_5: permittivity{anisotropic component1=1.1 component2=1.1 component3=0.45454545} permeability{anisotropic component1=1.1 component2=1.1 component3=0.45454545} dielectric_loss_tangent{anisotropic component1=1 component2=1 component3=-1} magnetic_loss_tangent{anisotropic component1=1 component2=1 component3=-1}
  PMLGroup1_XZ_5: permittivity{anisotropic component1=1 component2=0.01 component3=1} permeability{anisotropic component1=1 component2=0.01 component3=1} dielectric_loss_tangent{anisotropic component1=0 component2=242 component3=0} magnetic_loss_tangent{anisotropic component1=0 component2=242 component3=0}
  PMLGroup1_YZ_5: permittivity{anisotropic component1=0.01 component2=1 component3=1} permeability{anisotropic component1=0.01 component2=1 component3=1} dielectric_loss_tangent{anisotropic component1=242 component2=0 component3=0} magnetic_loss_tangent{anisotropic component1=242 component2=0 component3=0}
  PMLGroup1_XYZ_5: permittivity{anisotropic component1=1.1 component2=1.1 component3=1.1} permeability{anisotropic component1=1.1 component2=1.1 component3=1.1} dielectric_loss_tangent{anisotropic component1=1 component2=1 component3=1} magnetic_loss_tangent{anisotropic component1=1 component2=1 component3=1}
  PMLGroup1_Z_6: permittivity{anisotropic component1=1.1 component2=1.1 component3=0.45454545} permeability{anisotropic component1=1.1 component2=1.1 component3=0.45454545} dielectric_loss_tangent{anisotropic component1=1 component2=1 component3=-1} magnetic_loss_tangent{anisotropic component1=1 component2=1 component3=-1}
  PMLGroup1_XZ_6: permittivity{anisotropic component1=1 component2=0.01 component3=1} permeability{anisotropic component1=1 component2=0.01 component3=1} dielectric_loss_tangent{anisotropic component1=0 component2=242 component3=0} magnetic_loss_tangent{anisotropic component1=0 component2=242 component3=0}
  PMLGroup1_YZ_6: permittivity{anisotropic component1=0.01 component2=1 component3=1} permeability{anisotropic component1=0.01 component2=1 component3=1} dielectric_loss_tangent{anisotropic component1=242 component2=0 component3=0} magnetic_loss_tangent{anisotropic component1=242 component2=0 component3=0}
  PMLGroup1_XYZ_6: permittivity{anisotropic component1=1.1 component2=1.1 component3=1.1} permeability{anisotropic component1=1.1 component2=1.1 component3=1.1} dielectric_loss_tangent{anisotropic component1=1 component2=1 component3=1} magnetic_loss_tangent{anisotropic component1=1 component2=1 component3=1}
  PMLGroup1_Z_7: permittivity{anisotropic component1=1.1 component2=1.1 component3=0.45454545} permeability{anisotropic component1=1.1 component2=1.1 component3=0.45454545} dielectric_loss_tangent{anisotropic component1=1 component2=1 component3=-1} magnetic_loss_tangent{anisotropic component1=1 component2=1 component3=-1}
  PMLGroup1_XZ_7: permittivity{anisotropic component1=1 component2=0.01 component3=1} permeability{anisotropic component1=1 component2=0.01 component3=1} dielectric_loss_tangent{anisotropic component1=0 component2=242 component3=0} magnetic_loss_tangent{anisotropic component1=0 component2=242 component3=0}
  PMLGroup1_YZ_7: permittivity{anisotropic component1=0.01 component2=1 component3=1} permeability{anisotropic component1=0.01 component2=1 component3=1} dielectric_loss_tangent{anisotropic component1=242 component2=0 component3=0} magnetic_loss_tangent{anisotropic component1=242 component2=0 component3=0}
  PMLGroup1_XYZ_7: permittivity{anisotropic component1=1.1 component2=1.1 component3=1.1} permeability{anisotropic component1=1.1 component2=1.1 component3=1.1} dielectric_loss_tangent{anisotropic component1=1 component2=1 component3=1} magnetic_loss_tangent{anisotropic component1=1 component2=1 component3=1}
  PMLGroup1_Z_8: permittivity{anisotropic component1=1.1 component2=1.1 component3=0.45454545} permeability{anisotropic component1=1.1 component2=1.1 component3=0.45454545} dielectric_loss_tangent{anisotropic component1=1 component2=1 component3=-1} magnetic_loss_tangent{anisotropic component1=1 component2=1 component3=-1}
  PMLGroup1_XZ_8: permittivity{anisotropic component1=1 component2=0.01 component3=1} permeability{anisotropic component1=1 component2=0.01 component3=1} dielectric_loss_tangent{anisotropic component1=0 component2=242 component3=0} magnetic_loss_tangent{anisotropic component1=0 component2=242 component3=0}
  PMLGroup1_YZ_8: permittivity{anisotropic component1=0.01 component2=1 component3=1} permeability{anisotropic component1=0.01 component2=1 component3=1} dielectric_loss_tangent{anisotropic component1=242 component2=0 component3=0} magnetic_loss_tangent{anisotropic component1=242 component2=0 component3=0}
  PMLGroup1_XYZ_8: permittivity{anisotropic component1=1.1 component2=1.1 component3=1.1} permeability{anisotropic component1=1.1 component2=1.1 component3=1.1} dielectric_loss_tangent{anisotropic component1=1 component2=1 component3=1} magnetic_loss_tangent{anisotropic component1=1 component2=1 component3=1}

design 15G_5880_62mil15G (HFSS, DrivenModal, model units mm)
variables:
  w = 7.7mm
  l = 5.4mm
  l_feed = 6.6mm
  w_feed = 1.8mm
  gap = 1mm
  l_slot = 0.01mm
  cond = 1000000
  rough = 0.1um
  t = 2um
  w50 = 38mil
  R_core = 10mil
  R_pin = 5mil
  L_pin = 50mil
  R_out = (63.5/2) mil
  w_taper = 1mm
  l_taper = 1.2mm
  th = 1.6mm
  SMA_length = 4.24mm
  quarter_wave = 2.5mm
  w_quarter_wave = 1.8mm
  w_taper2 = 0.5mm
geometry:
  Box1 [Rogers RT/duroid 5880 (tm)] = box(corner=(-15mm, 0mm, -0.2mm), size=(30mm, 30mm, -th))
  Rectangle1 = rectangle(corner=(-w_feed/2, 0mm, 0mm), x_size=w_feed, y_size=l_feed)
  Rectangle2 = rectangle(corner=(-w/2, l_feed, 0mm), x_size=w, y_size=l)
  Rectangle3 = rectangle(corner=(-w_feed/2, l_feed, 0mm), x_size=-gap, y_size=l_slot)
  Rectangle3_1 = Rectangle3.duplicate_mirror(point=(0mm, 0mm, 0mm), normal=(1mm, 0mm, 0mm))
  Rectangle2.subtract(Rectangle3, Rectangle3_1)
  Rectangle2.unite(Rectangle1)
  Rectangle4 = rectangle(corner=(15mm, -0.1mm, -th-0.2mm), x_size=-30mm, y_size=30mm)
  Box2 [vacuum] = box(corner=(-20mm, -20mm, -20mm), size=(40mm, 60mm, 40mm))
  coordinate_system FaceCS1 = face of Box2: Origin=Box2.vertex(1 of 8) FaceID=Box2.face(+z) AxisPosn=Box2.vertex(2 of 8) WhichAxis=X
  PML_Box2_1 [PMLGroup1_Z_4, oriented by FaceCS1] = sweep_along_normal(Box2.face(+z), length=22.996598mm)
  coordinate_system FaceCS2 = face of Box2: Origin=Box2.vertex(5 of 8) FaceID=Box2.face(-z) AxisPosn=Box2.vertex(6 of 8) WhichAxis=X
  PML_Box2_2 [PMLGroup1_Z_4, oriented by FaceCS2] = sweep_along_normal(Box2.face(-z), length=22.996598mm)
  coordinate_system FaceCS3 = face of Box2: Origin=Box2.vertex(4 of 8) FaceID=Box2.face(-y) AxisPosn=Box2.vertex(7 of 8) WhichAxis=X
  PML_Box2_3 [PMLGroup1_Z_4, oriented by FaceCS3] = sweep_along_normal(Box2.face(-y), length=22.996598mm)
  coordinate_system FaceCS4 = face of Box2: Origin=Box2.vertex(3 of 8) FaceID=Box2.face(-x) AxisPosn=Box2.vertex(8 of 8) WhichAxis=X
  PML_Box2_4 [PMLGroup1_Z_4, oriented by FaceCS4] = sweep_along_normal(Box2.face(-x), length=22.996598mm)
  coordinate_system FaceCS5 = face of Box2: Origin=Box2.vertex(2 of 8) FaceID=Box2.face(+y) AxisPosn=Box2.vertex(5 of 8) WhichAxis=X
  PML_Box2_5 [PMLGroup1_Z_4, oriented by FaceCS5] = sweep_along_normal(Box2.face(+y), length=22.996598mm)
  coordinate_system FaceCS6 = face of Box2: Origin=Box2.vertex(1 of 8) FaceID=Box2.face(+x) AxisPosn=Box2.vertex(6 of 8) WhichAxis=X
  PML_Box2_6 [PMLGroup1_Z_4, oriented by FaceCS6] = sweep_along_normal(Box2.face(+x), length=22.996598mm)
  PML_Box2_7 [PMLGroup1_XZ_4, oriented by FaceCS3] = sweep_along_normal(PML_Box2_1.face(at (0, -20, 31.4983)), length=22.996598mm)
  PML_Box2_8 [PMLGroup1_XZ_4, oriented by FaceCS4] = sweep_along_normal(PML_Box2_1.face(at (-20, 10, 31.4983)), length=22.996598mm)
  PML_Box2_9 [PMLGroup1_XZ_4, oriented by FaceCS5] = sweep_along_normal(PML_Box2_1.face(at (0, 40, 31.4983)), length=22.996598mm)
  PML_Box2_10 [PMLGroup1_YZ_4, oriented by FaceCS1] = sweep_along_normal(PML_Box2_1.face(at (20, 10, 31.4983)), length=22.996598mm)
  coordinate_system FaceCS7 = face of Box2: Origin=Box2.vertex(6 of 8) FaceID=Box2.face(-z) AxisPosn=Box2.vertex(7 of 8) WhichAxis=X
  PML_Box2_11 [PMLGroup1_YZ_4, oriented by FaceCS7] = sweep_along_normal(PML_Box2_2.face(at (0, -20, -31.4983)), length=22.996598mm)
  coordinate_system FaceCS8 = face of Box2: Origin=Box2.vertex(7 of 8) FaceID=Box2.face(-z) AxisPosn=Box2.vertex(8 of 8) WhichAxis=X
  PML_Box2_12 [PMLGroup1_YZ_4, oriented by FaceCS8] = sweep_along_normal(PML_Box2_2.face(at (-20, 10, -31.4983)), length=22.996598mm)
  PML_Box2_13 [PMLGroup1_XZ_4, oriented by FaceCS2] = sweep_along_normal(PML_Box2_2.face(at (0, 40, -31.4983)), length=22.996598mm)
  PML_Box2_14 [PMLGroup1_YZ_4, oriented by FaceCS2] = sweep_along_normal(PML_Box2_2.face(at (20, 10, -31.4983)), length=22.996598mm)
  PML_Box2_15 [PMLGroup1_YZ_4, oriented by FaceCS3] = sweep_along_normal(PML_Box2_3.face(at (-20, -31.4983, 0)), length=22.996598mm)
  PML_Box2_16 [PMLGroup1_YZ_4, oriented by FaceCS6] = sweep_along_normal(PML_Box2_3.face(at (20, -31.4983, 0)), length=22.996598mm)
  PML_Box2_17 [PMLGroup1_YZ_4, oriented by FaceCS4] = sweep_along_normal(PML_Box2_4.face(at (-31.4983, 40, 0)), length=22.996598mm)
  PML_Box2_18 [PMLGroup1_YZ_4, oriented by FaceCS5] = sweep_along_normal(PML_Box2_5.face(at (20, 51.4983, 0)), length=22.996598mm)
  PML_Box2_19 [PMLGroup1_XYZ_4, oriented by FaceCS3] = sweep_along_normal(PML_Box2_7.face(at (-20, -31.4983, 31.4983)), length=22.996598mm)
  PML_Box2_20 [PMLGroup1_XYZ_4, oriented by FaceCS1] = sweep_along_normal(PML_Box2_7.face(at (20, -31.4983, 31.4983)), length=22.996598mm)
  PML_Box2_21 [PMLGroup1_XYZ_4, oriented by FaceCS4] = sweep_along_normal(PML_Box2_8.face(at (-31.4983, 40, 31.4983)), length=22.996598mm)
  PML_Box2_22 [PMLGroup1_XYZ_4, oriented by FaceCS5] = sweep_along_normal(PML_Box2_9.face(at (20, 51.4983, 31.4983)), length=22.996598mm)
  PML_Box2_23 [PMLGroup1_XYZ_4, oriented by FaceCS8] = sweep_along_normal(PML_Box2_11.face(at (-20, -31.4983, -31.4983)), length=22.996598mm)
  PML_Box2_24 [PMLGroup1_XYZ_4, oriented by FaceCS7] = sweep_along_normal(PML_Box2_11.face(at (20, -31.4983, -31.4983)), length=22.996598mm)
  coordinate_system FaceCS9 = face of Box2: Origin=Box2.vertex(8 of 8) FaceID=Box2.face(-z) AxisPosn=Box2.vertex(5 of 8) WhichAxis=X
  PML_Box2_25 [PMLGroup1_XYZ_4, oriented by FaceCS9] = sweep_along_normal(PML_Box2_12.face(at (-31.4983, 40, -31.4983)), length=22.996598mm)
  PML_Box2_26 [PMLGroup1_XYZ_4, oriented by FaceCS2] = sweep_along_normal(PML_Box2_13.face(at (20, 51.4983, -31.4983)), length=22.996598mm)
  Box3 [polyester] = box(corner=(-15mm, 0mm, 0mm), size=(30mm, 30mm, -0.2mm))
  Polyline1 = polyline(z=0mm, xy: (w_taper, 0mm) (w_feed/2, l_taper) (w_feed/2, 0mm) (w_taper, 0mm), closed, covered)
  Polyline1_1 = Polyline1.duplicate_mirror(point=(0mm, 0mm, 0mm), normal=(-1mm, 0mm, 0mm))
  Rectangle2.subtract(Polyline1, Polyline1_1)
  Rectangle2.move(0mm, quarter_wave, 0mm)
  Rectangle5 = rectangle(corner=(-w_quarter_wave/2, 0mm, 0mm), x_size=w_quarter_wave, y_size=quarter_wave)
  Rectangle2.unite(Rectangle5)
  Polyline2 = polyline(z=0mm, xy: (w_taper2, 0mm) (w_quarter_wave/2, 0mm) (w_quarter_wave/2, 1.4mm) (w_taper2, 0mm), closed, covered)
  Polyline2_1 = Polyline2.duplicate_mirror(point=(0mm, 0mm, 0mm), normal=(-1mm, 0mm, 0mm))
  Rectangle2.subtract(Polyline2, Polyline2_1)
  SMACore [copper] = cylinder(axis=Y, base_centre=(0mm, 0mm, 0mm), radius=R_core, height=-SMA_length)
  Core_1 = SMACore.copy()
  SMACore.move(0mm, -0.1mm, R_pin)
  SMAPin = cylinder(axis=Y, base_centre=(0mm, 0mm, 0mm), radius=R_pin, height=L_pin)
  SMAPin.move(0mm, -0.1mm, R_pin)
  SMACore.unite(SMAPin)
  185mmcore = cylinder(axis=Y, base_centre=(0mm, -4.24mm, 0mm), radius=0.8mm/2, height=-10.15mm)
  185mmcore_1 = 185mmcore.copy()
  185mmcore_2 = 185mmcore.copy()
  185mmcore.move(0mm, -0.1mm, R_pin)
  SMACore.unite(185mmcore)
  SMASub [Teflon (tm)] = cylinder(axis=Y, base_centre=(0mm, 0mm, 0mm), radius=R_out, height=-SMA_length)
  SMASub.subtract(Core_1)
  SMASub.move(0mm, -0.1mm, R_pin)
  SMAGND [brass] = cylinder(axis=Y, base_centre=(0mm, 0mm, 0mm), radius=2.5mm, height=-SMA_length)
  Box5 = box(corner=(-12.7mm/2, 0mm, 4.81mm), size=(12.7mm, -4.24mm, -9.53mm))
  Box6 = box(corner=(-12.7mm/2, 0.5mm, 4.81mm), size=(12.7mm, -4.24mm-0.5mm, -4.81mm-R_pin))
  Box5.unite(Box6)
  SMAGND.unite(Box5)
  Cylinder1 = cylinder(axis=Y, base_centre=(0mm, 0.5mm, 0mm), radius=R_out, height=-SMA_length-0.5mm)
  SMAGND.subtract(Cylinder1)
  SMAGND.move(0mm, -0.1mm, R_pin)
  Box4 = box(corner=(6.35mm/2, -0.1mm, 0mm), size=(6.35mm/2, 9.32mm-4.24mm, 4.81mm))
  Box4_1 = Box4.duplicate_mirror(point=(0mm, 0mm, 0mm), normal=(1mm, 0mm, 0mm))
  SMAGND.unite(Box4, Box4_1)
  185mmGND = cylinder(axis=Y, base_centre=(0mm, -4.24mm, 0mm), radius=4mm, height=-10.15mm)
  185mmsub [vacuum] = cylinder(axis=Y, base_centre=(0mm, -4.24mm, 0mm), radius=1.85mm/2, height=-10.15mm)
  185mmsub_1 = 185mmsub.copy()
  185mmGND.subtract(185mmcore_1, 185mmsub_1)
  185mmGND.move(0mm, -0.1mm, R_pin)
  SMAGND.unite(185mmGND)
  SMACylinder [pec] = cylinder(axis=Y, base_centre=(0mm, -SMA_length, 0mm), radius=4mm, height=-3mm)
  SMACylinder.move(0mm, -0.1mm, R_pin)
  SMACylinder.move(0mm, -10.15mm, 0mm)
  185mmsub.subtract(185mmcore_2)
  185mmsub.move(0mm, -0.1mm, R_pin)
  port = circle(normal=Y, centre=(0mm, -4.24mm-10.15mm, 0mm), radius=1.85mm/2)
  Circle2 = circle(normal=Y, centre=(0mm, -4.24mm-10.15mm, 0mm), radius=0.4mm)
  port.subtract(Circle2)
  port.move(0mm, -0.1mm, R_pin)
  group 1_85mm = SMACore, SMASub, SMAGND, SMACylinder, 185mmsub, port
boundaries and excitations:
  FiniteCond1: Finite Conductivity Objects=Rectangle4 Conductivity=58000000 Permeability=1 Thickness=35um Roughness=1um IsInternal
  FiniteCond2: Finite Conductivity Objects=Rectangle2 Conductivity=cond Permeability=1 Thickness=t Roughness=rough IsInternal
  PML_radiation1: Radiation Faces=Box2.face(+z) IsForPML
  PML_radiation2: Radiation Faces=Box2.face(-z) IsForPML
  PML_radiation3: Radiation Faces=Box2.face(-y) IsForPML
  PML_radiation4: Radiation Faces=Box2.face(-x) IsForPML
  PML_radiation5: Radiation Faces=Box2.face(+y) IsForPML
  PML_radiation6: Radiation Faces=Box2.face(+x) IsForPML
  1: Wave Port Objects=port NumModes=1 Modes{Mode1{CharImp=Zpi}}
setups:
  Setup1: HfssDriven Frequency=15GHz MaxDeltaS=0.02 MaximumPasses=20 MinimumPasses=1 MinimumConvergedPasses=1 PercentRefinement=30 BasisOrder=1 PortAccuracy=2
    sweep Sweep: 14GHz to 16GHz, 21 points; Type=Discrete SaveFields
source amplitudes:
  1:1: 1W 0deg
radiation setups:
  Infinite Sphere1: Infinite Sphere Theta=-180deg..180deg step 1deg Phi=-180deg..180deg step 1deg
field plots:
  Mag_E1: E Field over Rectangle2.face(#68) on Setup1 : LastAdaptive at Freq=15GHz Phase=0deg
reports:
  S Parameter Plot 1: dB(S(1,1)) vs Freq on Setup1 : Sweep; markers m1 at 13.9GHz
  S Parameter Chart 1: S(1,1) on Setup1 : Sweep [Freq=all]; markers m1 at 15GHz
  Gain Plot 1: dB(GainTotal) vs Phi, Theta on Setup1 : Sweep, Infinite Sphere1 [Freq=15.3GHz]
  Antenna Params Table 1: RadiationEfficiency vs Freq on Setup1 : LastAdaptive; RadiationEfficiency vs Freq on Setup1 : Sweep [Freq=14GHz,14.3GHz,14.5GHz,15GHz,15.5GHz,16GHz]
  VSWR Plot 1: VSWR(1) vs Freq on Setup1 : Sweep
  Gain Plot 2: dB(GainTotal) vs Theta on Setup1 : Sweep, Infinite Sphere1 [Phi=0deg,90deg Freq=15.5GHz]; markers m1 at 48deg

design 5G_5880_62mil5G (HFSS, DrivenModal, model units mm)
variables:
  w = 20.9mm
  l = 16.6mm
  l_feed = 12mm
  w_feed = 1.5mm
  gap = 1mm
  l_slot = 2.5mm
  cond = 58000000
  rough = 0.1um
  t = 18um
  w50 = 38mil
  R_core = 0.635mm
  R_pin = 0.1mm
  L_pin = 1.5mm
  R_out = 2.0574mm
  w_taper = 1mm
  l_taper = 1.2mm
  th = 1.6mm
  SMA_length = 1.5mm
  quarter_wave = 2.5mm
  w_quarter_wave = 1.8mm
  w_taper2 = 0.5mm
geometry:
  Box1 [Rogers RT/duroid 5880 (tm)] = box(corner=(-15mm, 0mm, -0.2mm), size=(30mm, 40mm, -th))
  Rectangle1 = rectangle(corner=(-w_feed/2, 0mm, 0mm), x_size=w_feed, y_size=l_feed)
  Rectangle2 = rectangle(corner=(-w/2, l_feed, 0mm), x_size=w, y_size=l)
  Rectangle3 = rectangle(corner=(-w_feed/2, l_feed, 0mm), x_size=-gap, y_size=l_slot)
  Rectangle3_1 = Rectangle3.duplicate_mirror(point=(0mm, 0mm, 0mm), normal=(1mm, 0mm, 0mm))
  Rectangle2.subtract(Rectangle3, Rectangle3_1)
  Rectangle2.unite(Rectangle1)
  Rectangle4 = rectangle(corner=(15mm, -0.1mm, -th-0.2mm), x_size=-30mm, y_size=40mm)
  Box2 [vacuum] = box(corner=(-20mm, -20mm, -20mm), size=(40mm, 60mm, 40mm))
  SMACore [copper] = cylinder(axis=Y, base_centre=(0mm, 0mm, 0mm), radius=R_core, height=-SMA_length)
  Core_1 = SMACore.copy()
  SMACore.move(0mm, -0.1mm, R_pin)
  SMAPin = cylinder(axis=Y, base_centre=(0mm, 0mm, 0mm), radius=R_pin, height=L_pin)
  SMAPin.move(0mm, -0.1mm, R_pin)
  SMACore.unite(SMAPin)
  SMACore_1 = SMACore.copy()
  SMASub [Teflon (tm)] = cylinder(axis=Y, base_centre=(0mm, 0mm, 0mm), radius=R_out, height=-SMA_length)
  Sub_1 = SMASub.copy()
  SMASub.subtract(Core_1)
  SMASub.move(0mm, -0.1mm, R_pin)
  SMASub.subtract(SMACore_1)
  SMAGND [brass] = cylinder(axis=Y, base_centre=(0mm, 0mm, 0mm), radius=2.5mm, height=-SMA_length)
  Cylinder5 = cylinder(axis=Y, base_centre=(0mm, 0mm, 0mm), radius=4mm, height=-1mm)
  SMAGND.unite(Cylinder5)
  SMAGND.subtract(Sub_1)
  SMAGND.move(0mm, -0.1mm, R_pin)
  SMAport1 = circle(normal=Y, centre=(0mm, -SMA_length, 0mm), radius=R_out)
  Circle1 = circle(normal=Y, centre=(0mm, -7.62mm, 0mm), radius=R_core)
  SMAport1.subtract(Circle1)
  SMAport1.move(0mm, -0.1mm, R_pin)
  SMACylinder [pec] = cylinder(axis=Y, base_centre=(0mm, -SMA_length, 0mm), radius=2.5mm, height=-3mm)
  SMACylinder.move(0mm, -0.1mm, R_pin)
  coordinate_system FaceCS1 = face of Box2: Origin=Box2.vertex(1 of 8) FaceID=Box2.face(+z) AxisPosn=Box2.vertex(2 of 8) WhichAxis=X
  PML_Box2_1 [PMLGroup1_Z_5, oriented by FaceCS1] = sweep_along_normal(Box2.face(+z), length=22.996598mm)
  coordinate_system FaceCS2 = face of Box2: Origin=Box2.vertex(5 of 8) FaceID=Box2.face(-z) AxisPosn=Box2.vertex(6 of 8) WhichAxis=X
  PML_Box2_2 [PMLGroup1_Z_5, oriented by FaceCS2] = sweep_along_normal(Box2.face(-z), length=22.996598mm)
  coordinate_system FaceCS3 = face of Box2: Origin=Box2.vertex(4 of 8) FaceID=Box2.face(-y) AxisPosn=Box2.vertex(7 of 8) WhichAxis=X
  PML_Box2_3 [PMLGroup1_Z_5, oriented by FaceCS3] = sweep_along_normal(Box2.face(-y), length=22.996598mm)
  coordinate_system FaceCS4 = face of Box2: Origin=Box2.vertex(3 of 8) FaceID=Box2.face(-x) AxisPosn=Box2.vertex(8 of 8) WhichAxis=X
  PML_Box2_4 [PMLGroup1_Z_5, oriented by FaceCS4] = sweep_along_normal(Box2.face(-x), length=22.996598mm)
  coordinate_system FaceCS5 = face of Box2: Origin=Box2.vertex(2 of 8) FaceID=Box2.face(+y) AxisPosn=Box2.vertex(5 of 8) WhichAxis=X
  PML_Box2_5 [PMLGroup1_Z_5, oriented by FaceCS5] = sweep_along_normal(Box2.face(+y), length=22.996598mm)
  coordinate_system FaceCS6 = face of Box2: Origin=Box2.vertex(1 of 8) FaceID=Box2.face(+x) AxisPosn=Box2.vertex(6 of 8) WhichAxis=X
  PML_Box2_6 [PMLGroup1_Z_5, oriented by FaceCS6] = sweep_along_normal(Box2.face(+x), length=22.996598mm)
  PML_Box2_7 [PMLGroup1_XZ_5, oriented by FaceCS3] = sweep_along_normal(PML_Box2_1.face(at (0, -20, 31.4983)), length=22.996598mm)
  PML_Box2_8 [PMLGroup1_XZ_5, oriented by FaceCS4] = sweep_along_normal(PML_Box2_1.face(at (-20, 10, 31.4983)), length=22.996598mm)
  PML_Box2_9 [PMLGroup1_XZ_5, oriented by FaceCS5] = sweep_along_normal(PML_Box2_1.face(at (0, 40, 31.4983)), length=22.996598mm)
  PML_Box2_10 [PMLGroup1_YZ_5, oriented by FaceCS1] = sweep_along_normal(PML_Box2_1.face(at (20, 10, 31.4983)), length=22.996598mm)
  coordinate_system FaceCS7 = face of Box2: Origin=Box2.vertex(6 of 8) FaceID=Box2.face(-z) AxisPosn=Box2.vertex(7 of 8) WhichAxis=X
  PML_Box2_11 [PMLGroup1_YZ_5, oriented by FaceCS7] = sweep_along_normal(PML_Box2_2.face(at (0, -20, -31.4983)), length=22.996598mm)
  coordinate_system FaceCS8 = face of Box2: Origin=Box2.vertex(7 of 8) FaceID=Box2.face(-z) AxisPosn=Box2.vertex(8 of 8) WhichAxis=X
  PML_Box2_12 [PMLGroup1_YZ_5, oriented by FaceCS8] = sweep_along_normal(PML_Box2_2.face(at (-20, 10, -31.4983)), length=22.996598mm)
  PML_Box2_13 [PMLGroup1_XZ_5, oriented by FaceCS2] = sweep_along_normal(PML_Box2_2.face(at (0, 40, -31.4983)), length=22.996598mm)
  PML_Box2_14 [PMLGroup1_YZ_5, oriented by FaceCS2] = sweep_along_normal(PML_Box2_2.face(at (20, 10, -31.4983)), length=22.996598mm)
  PML_Box2_15 [PMLGroup1_YZ_5, oriented by FaceCS3] = sweep_along_normal(PML_Box2_3.face(at (-20, -31.4983, 0)), length=22.996598mm)
  PML_Box2_16 [PMLGroup1_YZ_5, oriented by FaceCS6] = sweep_along_normal(PML_Box2_3.face(at (20, -31.4983, 0)), length=22.996598mm)
  PML_Box2_17 [PMLGroup1_YZ_5, oriented by FaceCS4] = sweep_along_normal(PML_Box2_4.face(at (-31.4983, 40, 0)), length=22.996598mm)
  PML_Box2_18 [PMLGroup1_YZ_5, oriented by FaceCS5] = sweep_along_normal(PML_Box2_5.face(at (20, 51.4983, 0)), length=22.996598mm)
  PML_Box2_19 [PMLGroup1_XYZ_5, oriented by FaceCS3] = sweep_along_normal(PML_Box2_7.face(at (-20, -31.4983, 31.4983)), length=22.996598mm)
  PML_Box2_20 [PMLGroup1_XYZ_5, oriented by FaceCS1] = sweep_along_normal(PML_Box2_7.face(at (20, -31.4983, 31.4983)), length=22.996598mm)
  PML_Box2_21 [PMLGroup1_XYZ_5, oriented by FaceCS4] = sweep_along_normal(PML_Box2_8.face(at (-31.4983, 40, 31.4983)), length=22.996598mm)
  PML_Box2_22 [PMLGroup1_XYZ_5, oriented by FaceCS5] = sweep_along_normal(PML_Box2_9.face(at (20, 51.4983, 31.4983)), length=22.996598mm)
  PML_Box2_23 [PMLGroup1_XYZ_5, oriented by FaceCS8] = sweep_along_normal(PML_Box2_11.face(at (-20, -31.4983, -31.4983)), length=22.996598mm)
  PML_Box2_24 [PMLGroup1_XYZ_5, oriented by FaceCS7] = sweep_along_normal(PML_Box2_11.face(at (20, -31.4983, -31.4983)), length=22.996598mm)
  coordinate_system FaceCS9 = face of Box2: Origin=Box2.vertex(8 of 8) FaceID=Box2.face(-z) AxisPosn=Box2.vertex(5 of 8) WhichAxis=X
  PML_Box2_25 [PMLGroup1_XYZ_5, oriented by FaceCS9] = sweep_along_normal(PML_Box2_12.face(at (-31.4983, 40, -31.4983)), length=22.996598mm)
  PML_Box2_26 [PMLGroup1_XYZ_5, oriented by FaceCS2] = sweep_along_normal(PML_Box2_13.face(at (20, 51.4983, -31.4983)), length=22.996598mm)
  Box3 [polyester] = box(corner=(-15mm, 0mm, 0mm), size=(30mm, 30mm, -0.2mm))
  Polyline1 = polyline(z=0mm, xy in mm: (-0.4, 0) (-1, 1) (-1, 0) (-0.4, 0), closed, covered)
  Polyline1_1 = Polyline1.duplicate_mirror(point=(0mm, 0mm, 0mm), normal=(1mm, 0mm, 0mm))
  Rectangle2.subtract(Polyline1, Polyline1_1)
  group SMA_Group = SMACore, SMASub, SMAGND, SMAport1, SMACylinder
boundaries and excitations:
  FiniteCond1: Finite Conductivity Objects=Rectangle4 Conductivity=58000000 Permeability=1 Thickness=35um Roughness=1um IsInternal
  FiniteCond2: Finite Conductivity Objects=Rectangle2 Conductivity=cond Permeability=1 Thickness=t Roughness=rough IsInternal
  PML_radiation1: Radiation Faces=Box2.face(+z) IsForPML
  PML_radiation2: Radiation Faces=Box2.face(-z) IsForPML
  PML_radiation3: Radiation Faces=Box2.face(-y) IsForPML
  PML_radiation4: Radiation Faces=Box2.face(-x) IsForPML
  PML_radiation5: Radiation Faces=Box2.face(+y) IsForPML
  PML_radiation6: Radiation Faces=Box2.face(+x) IsForPML
  1: Wave Port Objects=SMAport1 NumModes=1 DeembedDist=-2mm Modes{Mode1{CharImp=Zpi}}
setups:
  Setup1: HfssDriven Frequency=5GHz MaxDeltaS=0.02 MaximumPasses=20 MinimumPasses=1 MinimumConvergedPasses=1 PercentRefinement=30 BasisOrder=1 PortAccuracy=2
    sweep Sweep: 4GHz to 6GHz, 21 points; Type=Discrete SaveFields
source amplitudes:
  1:1: 1W 0deg
radiation setups:
  Infinite Sphere1: Infinite Sphere Theta=-180deg..180deg step 1deg Phi=-180deg..180deg step 1deg
field plots:
  Mag_E1: E Field over Rectangle2.face(at (0, 20.3, 0)) on Setup1 : LastAdaptive at Freq=5GHz Phase=0deg
reports:
  S Parameter Plot 1: dB(S(1,1)) vs Freq on Setup1 : Sweep; markers m1 at 13.9GHz
  S Parameter Chart 1: S(1,1) on Setup1 : Sweep [Freq=all gap=all quarter_wave=all]; markers m1 at 5.3GHz
  Gain Plot 1: dB(GainTotal) vs Phi, Theta on Setup1 : Sweep, Infinite Sphere1 [Freq=5GHz]
  Antenna Params Table 1: RadiationEfficiency vs Freq on Setup1 : LastAdaptive; RadiationEfficiency vs Freq on Setup1 : Sweep [Freq=4GHz,4.2GHz,4.4GHz,4.6GHz,4.8GHz,5GHz,5.2GHz,5.4GHz,5.6GHz,5.8GHz,6GHz]
  VSWR Plot 1: VSWR(1) vs Freq on Setup1 : Sweep
  Gain Plot 2: dB(GainTotal) vs Theta on Setup1 : Sweep, Infinite Sphere1 [Phi=90deg Freq=5.7GHz]; markers m1 at 2deg

design 10G_5880_62mil10G (HFSS, DrivenModal, model units mm)
variables:
  w = 11.5mm
  l = 8.5mm
  l_feed = 6mm
  w_feed = 1.8mm
  gap = 1mm
  l_slot = 0.01mm
  cond = 800000
  rough = 0.1um
  t = 2um
  w50 = 38mil
  R_core = 0.635mm
  R_pin = 0.1mm
  L_pin = 1.5mm
  R_out = 2.0574mm
  w_taper = 1mm
  l_taper = 1.2mm
  th = 1.6mm
  SMA_length = 1.5mm
  quarter_wave = 2.5mm
  w_quarter_wave = 1.8mm
  w_taper2 = 0.5mm
geometry:
  Box1 [Rogers RT/duroid 5880 (tm)] = box(corner=(-15mm, 0mm, -0.2mm), size=(30mm, 30mm, -th))
  Rectangle1 = rectangle(corner=(-w_feed/2, 0mm, 0mm), x_size=w_feed, y_size=l_feed)
  Rectangle2 = rectangle(corner=(-w/2, l_feed, 0mm), x_size=w, y_size=l)
  Rectangle3 = rectangle(corner=(-w_feed/2, l_feed, 0mm), x_size=-gap, y_size=l_slot)
  Rectangle3_1 = Rectangle3.duplicate_mirror(point=(0mm, 0mm, 0mm), normal=(1mm, 0mm, 0mm))
  Rectangle2.subtract(Rectangle3, Rectangle3_1)
  Rectangle2.unite(Rectangle1)
  Rectangle4 = rectangle(corner=(15mm, -0.1mm, -th-0.2mm), x_size=-30mm, y_size=30mm)
  Box2 [vacuum] = box(corner=(-20mm, -20mm, -20mm), size=(40mm, 60mm, 40mm))
  SMACore [copper] = cylinder(axis=Y, base_centre=(0mm, 0mm, 0mm), radius=R_core, height=-SMA_length)
  Core_1 = SMACore.copy()
  SMACore.move(0mm, -0.1mm, R_pin)
  SMAPin = cylinder(axis=Y, base_centre=(0mm, 0mm, 0mm), radius=R_pin, height=L_pin)
  SMAPin.move(0mm, -0.1mm, R_pin)
  SMACore.unite(SMAPin)
  SMACore_1 = SMACore.copy()
  SMASub [Teflon (tm)] = cylinder(axis=Y, base_centre=(0mm, 0mm, 0mm), radius=R_out, height=-SMA_length)
  Sub_1 = SMASub.copy()
  SMASub.subtract(Core_1)
  SMASub.move(0mm, -0.1mm, R_pin)
  SMASub.subtract(SMACore_1)
  SMAGND [brass] = cylinder(axis=Y, base_centre=(0mm, 0mm, 0mm), radius=2.5mm, height=-SMA_length)
  Cylinder5 = cylinder(axis=Y, base_centre=(0mm, 0mm, 0mm), radius=4mm, height=-1mm)
  SMAGND.unite(Cylinder5)
  SMAGND.subtract(Sub_1)
  SMAGND.move(0mm, -0.1mm, R_pin)
  SMAport1 = circle(normal=Y, centre=(0mm, -SMA_length, 0mm), radius=R_out)
  Circle1 = circle(normal=Y, centre=(0mm, -7.62mm, 0mm), radius=R_core)
  SMAport1.subtract(Circle1)
  SMAport1.move(0mm, -0.1mm, R_pin)
  SMACylinder [pec] = cylinder(axis=Y, base_centre=(0mm, -SMA_length, 0mm), radius=2.5mm, height=-3mm)
  SMACylinder.move(0mm, -0.1mm, R_pin)
  coordinate_system FaceCS1 = face of Box2: Origin=Box2.vertex(1 of 8) FaceID=Box2.face(+z) AxisPosn=Box2.vertex(2 of 8) WhichAxis=X
  PML_Box2_1 [PMLGroup1_Z_6, oriented by FaceCS1] = sweep_along_normal(Box2.face(+z), length=22.996598mm)
  coordinate_system FaceCS2 = face of Box2: Origin=Box2.vertex(5 of 8) FaceID=Box2.face(-z) AxisPosn=Box2.vertex(6 of 8) WhichAxis=X
  PML_Box2_2 [PMLGroup1_Z_6, oriented by FaceCS2] = sweep_along_normal(Box2.face(-z), length=22.996598mm)
  coordinate_system FaceCS3 = face of Box2: Origin=Box2.vertex(4 of 8) FaceID=Box2.face(-y) AxisPosn=Box2.vertex(7 of 8) WhichAxis=X
  PML_Box2_3 [PMLGroup1_Z_6, oriented by FaceCS3] = sweep_along_normal(Box2.face(-y), length=22.996598mm)
  coordinate_system FaceCS4 = face of Box2: Origin=Box2.vertex(3 of 8) FaceID=Box2.face(-x) AxisPosn=Box2.vertex(8 of 8) WhichAxis=X
  PML_Box2_4 [PMLGroup1_Z_6, oriented by FaceCS4] = sweep_along_normal(Box2.face(-x), length=22.996598mm)
  coordinate_system FaceCS5 = face of Box2: Origin=Box2.vertex(2 of 8) FaceID=Box2.face(+y) AxisPosn=Box2.vertex(5 of 8) WhichAxis=X
  PML_Box2_5 [PMLGroup1_Z_6, oriented by FaceCS5] = sweep_along_normal(Box2.face(+y), length=22.996598mm)
  coordinate_system FaceCS6 = face of Box2: Origin=Box2.vertex(1 of 8) FaceID=Box2.face(+x) AxisPosn=Box2.vertex(6 of 8) WhichAxis=X
  PML_Box2_6 [PMLGroup1_Z_6, oriented by FaceCS6] = sweep_along_normal(Box2.face(+x), length=22.996598mm)
  PML_Box2_7 [PMLGroup1_XZ_6, oriented by FaceCS3] = sweep_along_normal(PML_Box2_1.face(at (0, -20, 31.4983)), length=22.996598mm)
  PML_Box2_8 [PMLGroup1_XZ_6, oriented by FaceCS4] = sweep_along_normal(PML_Box2_1.face(at (-20, 10, 31.4983)), length=22.996598mm)
  PML_Box2_9 [PMLGroup1_XZ_6, oriented by FaceCS5] = sweep_along_normal(PML_Box2_1.face(at (0, 40, 31.4983)), length=22.996598mm)
  PML_Box2_10 [PMLGroup1_YZ_6, oriented by FaceCS1] = sweep_along_normal(PML_Box2_1.face(at (20, 10, 31.4983)), length=22.996598mm)
  coordinate_system FaceCS7 = face of Box2: Origin=Box2.vertex(6 of 8) FaceID=Box2.face(-z) AxisPosn=Box2.vertex(7 of 8) WhichAxis=X
  PML_Box2_11 [PMLGroup1_YZ_6, oriented by FaceCS7] = sweep_along_normal(PML_Box2_2.face(at (0, -20, -31.4983)), length=22.996598mm)
  coordinate_system FaceCS8 = face of Box2: Origin=Box2.vertex(7 of 8) FaceID=Box2.face(-z) AxisPosn=Box2.vertex(8 of 8) WhichAxis=X
  PML_Box2_12 [PMLGroup1_YZ_6, oriented by FaceCS8] = sweep_along_normal(PML_Box2_2.face(at (-20, 10, -31.4983)), length=22.996598mm)
  PML_Box2_13 [PMLGroup1_XZ_6, oriented by FaceCS2] = sweep_along_normal(PML_Box2_2.face(at (0, 40, -31.4983)), length=22.996598mm)
  PML_Box2_14 [PMLGroup1_YZ_6, oriented by FaceCS2] = sweep_along_normal(PML_Box2_2.face(at (20, 10, -31.4983)), length=22.996598mm)
  PML_Box2_15 [PMLGroup1_YZ_6, oriented by FaceCS3] = sweep_along_normal(PML_Box2_3.face(at (-20, -31.4983, 0)), length=22.996598mm)
  PML_Box2_16 [PMLGroup1_YZ_6, oriented by FaceCS6] = sweep_along_normal(PML_Box2_3.face(at (20, -31.4983, 0)), length=22.996598mm)
  PML_Box2_17 [PMLGroup1_YZ_6, oriented by FaceCS4] = sweep_along_normal(PML_Box2_4.face(at (-31.4983, 40, 0)), length=22.996598mm)
  PML_Box2_18 [PMLGroup1_YZ_6, oriented by FaceCS5] = sweep_along_normal(PML_Box2_5.face(at (20, 51.4983, 0)), length=22.996598mm)
  PML_Box2_19 [PMLGroup1_XYZ_6, oriented by FaceCS3] = sweep_along_normal(PML_Box2_7.face(at (-20, -31.4983, 31.4983)), length=22.996598mm)
  PML_Box2_20 [PMLGroup1_XYZ_6, oriented by FaceCS1] = sweep_along_normal(PML_Box2_7.face(at (20, -31.4983, 31.4983)), length=22.996598mm)
  PML_Box2_21 [PMLGroup1_XYZ_6, oriented by FaceCS4] = sweep_along_normal(PML_Box2_8.face(at (-31.4983, 40, 31.4983)), length=22.996598mm)
  PML_Box2_22 [PMLGroup1_XYZ_6, oriented by FaceCS5] = sweep_along_normal(PML_Box2_9.face(at (20, 51.4983, 31.4983)), length=22.996598mm)
  PML_Box2_23 [PMLGroup1_XYZ_6, oriented by FaceCS8] = sweep_along_normal(PML_Box2_11.face(at (-20, -31.4983, -31.4983)), length=22.996598mm)
  PML_Box2_24 [PMLGroup1_XYZ_6, oriented by FaceCS7] = sweep_along_normal(PML_Box2_11.face(at (20, -31.4983, -31.4983)), length=22.996598mm)
  coordinate_system FaceCS9 = face of Box2: Origin=Box2.vertex(8 of 8) FaceID=Box2.face(-z) AxisPosn=Box2.vertex(5 of 8) WhichAxis=X
  PML_Box2_25 [PMLGroup1_XYZ_6, oriented by FaceCS9] = sweep_along_normal(PML_Box2_12.face(at (-31.4983, 40, -31.4983)), length=22.996598mm)
  PML_Box2_26 [PMLGroup1_XYZ_6, oriented by FaceCS2] = sweep_along_normal(PML_Box2_13.face(at (20, 51.4983, -31.4983)), length=22.996598mm)
  Box3 [polyester] = box(corner=(-15mm, 0mm, 0mm), size=(30mm, 30mm, -0.2mm))
  group SMA_Group = SMACore, SMASub, SMAGND, SMAport1, SMACylinder
boundaries and excitations:
  FiniteCond1: Finite Conductivity Objects=Rectangle4 Conductivity=58000000 Permeability=1 Thickness=35um Roughness=1um IsInternal
  FiniteCond2: Finite Conductivity Objects=Rectangle2 Conductivity=cond Permeability=1 Thickness=t Roughness=rough IsInternal
  PML_radiation1: Radiation Faces=Box2.face(+z) IsForPML
  PML_radiation2: Radiation Faces=Box2.face(-z) IsForPML
  PML_radiation3: Radiation Faces=Box2.face(-y) IsForPML
  PML_radiation4: Radiation Faces=Box2.face(-x) IsForPML
  PML_radiation5: Radiation Faces=Box2.face(+y) IsForPML
  PML_radiation6: Radiation Faces=Box2.face(+x) IsForPML
  1: Wave Port Objects=SMAport1 NumModes=1 Modes{Mode1{CharImp=Zpi}}
setups:
  Setup1: HfssDriven Frequency=10GHz MaxDeltaS=0.02 MaximumPasses=20 MinimumPasses=1 MinimumConvergedPasses=1 PercentRefinement=30 BasisOrder=1 PortAccuracy=2
    sweep Sweep: 8GHz to 12GHz, 21 points; Type=Discrete SaveFields
source amplitudes:
  1:1: 1W 0deg
radiation setups:
  Infinite Sphere1: Infinite Sphere Theta=-180deg..180deg step 1deg Phi=-180deg..180deg step 1deg
field plots:
  Mag_E1: E Field over Rectangle2.face(at (0, 10.25, 0)) on Setup1 : LastAdaptive at Freq=10GHz Phase=0deg
reports:
  S Parameter Plot 1: dB(S(1,1)) vs Freq on Setup1 : Sweep; markers m1 at 13.9GHz
  S Parameter Chart 1: S(1,1) on Setup1 : Sweep [Freq=all quarter_wave=all]; markers m1 at 5GHz
  Gain Plot 1: dB(GainTotal) vs Phi, Theta on Setup1 : Sweep, Infinite Sphere1 [Freq=5GHz]
  Antenna Params Table 1: RadiationEfficiency vs Freq on Setup1 : LastAdaptive; RadiationEfficiency vs Freq on Setup1 : Sweep [Freq=8.4GHz,8.8GHz,9.2GHz,10GHz,11GHz]
  VSWR Plot 1: VSWR(1) vs Freq on Setup1 : Sweep
  Gain Plot 2: dB(GainTotal) vs Theta on Setup1 : Sweep, Infinite Sphere1 [Phi=90deg Freq=10GHz]; markers m1 at 2deg

design 5G_5880_62milcoaxial (HFSS, DrivenModal, model units mm)
variables:
  w = 20.9mm
  l = 16.6mm
  l_feed = 5mm
  w_feed = 2mm
  gap = 1mm
  l_slot = 3mm
  cond = 800000
  rough = 0.1um
  t = 2um
  w50 = 38mil
  R_core = 0.635mm
  R_pin = 0.1mm
  L_pin = 1.8mm
  R_out = 2.0574mm
  w_taper = 1mm
  l_taper = 1.2mm
  th = 1.6mm
  SMA_length = 1.5mm
  quarter_wave = 2.5mm
  w_quarter_wave = 1.8mm
  w_taper2 = 0.5mm
geometry:
  Box1 [Rogers RT/duroid 5880 (tm)] = box(corner=(-15mm, 0mm, -0.2mm), size=(30mm, 40mm, -th))
  Rectangle2 = rectangle(corner=(-w/2, l_feed, 0mm), x_size=w, y_size=l)
  Rectangle4 = rectangle(corner=(15mm, -0.1mm, -th-0.2mm), x_size=-30mm, y_size=40mm)
  Box2 [vacuum] = box(corner=(-20mm, -20mm, -20mm), size=(40mm, 60mm, 40mm))
  SMACore [copper] = cylinder(axis=Y, base_centre=(0mm, 0mm, 0mm), radius=R_core, height=-SMA_length)
  Core_1 = SMACore.copy()
  SMACore.move(0mm, -0.1mm, R_pin)
  SMAPin = cylinder(axis=Y, base_centre=(0mm, 0mm, 0mm), radius=R_pin, height=L_pin)
  SMAPin.move(0mm, -0.1mm, R_pin)
  SMACore.unite(SMAPin)
  SMACore_1 = SMACore.copy()
  SMASub [Teflon (tm)] = cylinder(axis=Y, base_centre=(0mm, 0mm, 0mm), radius=R_out, height=-SMA_length)
  Sub_1 = SMASub.copy()
  SMASub.subtract(Core_1)
  SMASub.move(0mm, -0.1mm, R_pin)
  SMASub.subtract(SMACore_1)
  SMAGND [brass] = cylinder(axis=Y, base_centre=(0mm, 0mm, 0mm), radius=2.5mm, height=-SMA_length)
  Cylinder5 = cylinder(axis=Y, base_centre=(0mm, 0mm, 0mm), radius=4mm, height=-1mm)
  SMAGND.unite(Cylinder5)
  SMAGND.subtract(Sub_1)
  SMAGND.move(0mm, -0.1mm, R_pin)
  SMAport1 = circle(normal=Y, centre=(0mm, -SMA_length, 0mm), radius=R_out)
  Circle1 = circle(normal=Y, centre=(0mm, -7.62mm, 0mm), radius=R_core)
  SMAport1.subtract(Circle1)
  SMAport1.move(0mm, -0.1mm, R_pin)
  SMACylinder [pec] = cylinder(axis=Y, base_centre=(0mm, -SMA_length, 0mm), radius=2.5mm, height=-3mm)
  SMACylinder.move(0mm, -0.1mm, R_pin)
  coordinate_system FaceCS1 = face of Box2: Origin=Box2.vertex(1 of 8) FaceID=Box2.face(+z) AxisPosn=Box2.vertex(2 of 8) WhichAxis=X
  PML_Box2_1 [PMLGroup1_Z_7, oriented by FaceCS1] = sweep_along_normal(Box2.face(+z), length=22.996598mm)
  coordinate_system FaceCS2 = face of Box2: Origin=Box2.vertex(5 of 8) FaceID=Box2.face(-z) AxisPosn=Box2.vertex(6 of 8) WhichAxis=X
  PML_Box2_2 [PMLGroup1_Z_7, oriented by FaceCS2] = sweep_along_normal(Box2.face(-z), length=22.996598mm)
  coordinate_system FaceCS3 = face of Box2: Origin=Box2.vertex(4 of 8) FaceID=Box2.face(-y) AxisPosn=Box2.vertex(7 of 8) WhichAxis=X
  PML_Box2_3 [PMLGroup1_Z_7, oriented by FaceCS3] = sweep_along_normal(Box2.face(-y), length=22.996598mm)
  coordinate_system FaceCS4 = face of Box2: Origin=Box2.vertex(3 of 8) FaceID=Box2.face(-x) AxisPosn=Box2.vertex(8 of 8) WhichAxis=X
  PML_Box2_4 [PMLGroup1_Z_7, oriented by FaceCS4] = sweep_along_normal(Box2.face(-x), length=22.996598mm)
  coordinate_system FaceCS5 = face of Box2: Origin=Box2.vertex(2 of 8) FaceID=Box2.face(+y) AxisPosn=Box2.vertex(5 of 8) WhichAxis=X
  PML_Box2_5 [PMLGroup1_Z_7, oriented by FaceCS5] = sweep_along_normal(Box2.face(+y), length=22.996598mm)
  coordinate_system FaceCS6 = face of Box2: Origin=Box2.vertex(1 of 8) FaceID=Box2.face(+x) AxisPosn=Box2.vertex(6 of 8) WhichAxis=X
  PML_Box2_6 [PMLGroup1_Z_7, oriented by FaceCS6] = sweep_along_normal(Box2.face(+x), length=22.996598mm)
  PML_Box2_7 [PMLGroup1_XZ_7, oriented by FaceCS3] = sweep_along_normal(PML_Box2_1.face(at (0, -20, 31.4983)), length=22.996598mm)
  PML_Box2_8 [PMLGroup1_XZ_7, oriented by FaceCS4] = sweep_along_normal(PML_Box2_1.face(at (-20, 10, 31.4983)), length=22.996598mm)
  PML_Box2_9 [PMLGroup1_XZ_7, oriented by FaceCS5] = sweep_along_normal(PML_Box2_1.face(at (0, 40, 31.4983)), length=22.996598mm)
  PML_Box2_10 [PMLGroup1_YZ_7, oriented by FaceCS1] = sweep_along_normal(PML_Box2_1.face(at (20, 10, 31.4983)), length=22.996598mm)
  coordinate_system FaceCS7 = face of Box2: Origin=Box2.vertex(6 of 8) FaceID=Box2.face(-z) AxisPosn=Box2.vertex(7 of 8) WhichAxis=X
  PML_Box2_11 [PMLGroup1_YZ_7, oriented by FaceCS7] = sweep_along_normal(PML_Box2_2.face(at (0, -20, -31.4983)), length=22.996598mm)
  coordinate_system FaceCS8 = face of Box2: Origin=Box2.vertex(7 of 8) FaceID=Box2.face(-z) AxisPosn=Box2.vertex(8 of 8) WhichAxis=X
  PML_Box2_12 [PMLGroup1_YZ_7, oriented by FaceCS8] = sweep_along_normal(PML_Box2_2.face(at (-20, 10, -31.4983)), length=22.996598mm)
  PML_Box2_13 [PMLGroup1_XZ_7, oriented by FaceCS2] = sweep_along_normal(PML_Box2_2.face(at (0, 40, -31.4983)), length=22.996598mm)
  PML_Box2_14 [PMLGroup1_YZ_7, oriented by FaceCS2] = sweep_along_normal(PML_Box2_2.face(at (20, 10, -31.4983)), length=22.996598mm)
  PML_Box2_15 [PMLGroup1_YZ_7, oriented by FaceCS3] = sweep_along_normal(PML_Box2_3.face(at (-20, -31.4983, 0)), length=22.996598mm)
  PML_Box2_16 [PMLGroup1_YZ_7, oriented by FaceCS6] = sweep_along_normal(PML_Box2_3.face(at (20, -31.4983, 0)), length=22.996598mm)
  PML_Box2_17 [PMLGroup1_YZ_7, oriented by FaceCS4] = sweep_along_normal(PML_Box2_4.face(at (-31.4983, 40, 0)), length=22.996598mm)
  PML_Box2_18 [PMLGroup1_YZ_7, oriented by FaceCS5] = sweep_along_normal(PML_Box2_5.face(at (20, 51.4983, 0)), length=22.996598mm)
  PML_Box2_19 [PMLGroup1_XYZ_7, oriented by FaceCS3] = sweep_along_normal(PML_Box2_7.face(at (-20, -31.4983, 31.4983)), length=22.996598mm)
  PML_Box2_20 [PMLGroup1_XYZ_7, oriented by FaceCS1] = sweep_along_normal(PML_Box2_7.face(at (20, -31.4983, 31.4983)), length=22.996598mm)
  PML_Box2_21 [PMLGroup1_XYZ_7, oriented by FaceCS4] = sweep_along_normal(PML_Box2_8.face(at (-31.4983, 40, 31.4983)), length=22.996598mm)
  PML_Box2_22 [PMLGroup1_XYZ_7, oriented by FaceCS5] = sweep_along_normal(PML_Box2_9.face(at (20, 51.4983, 31.4983)), length=22.996598mm)
  PML_Box2_23 [PMLGroup1_XYZ_7, oriented by FaceCS8] = sweep_along_normal(PML_Box2_11.face(at (-20, -31.4983, -31.4983)), length=22.996598mm)
  PML_Box2_24 [PMLGroup1_XYZ_7, oriented by FaceCS7] = sweep_along_normal(PML_Box2_11.face(at (20, -31.4983, -31.4983)), length=22.996598mm)
  coordinate_system FaceCS9 = face of Box2: Origin=Box2.vertex(8 of 8) FaceID=Box2.face(-z) AxisPosn=Box2.vertex(5 of 8) WhichAxis=X
  PML_Box2_25 [PMLGroup1_XYZ_7, oriented by FaceCS9] = sweep_along_normal(PML_Box2_12.face(at (-31.4983, 40, -31.4983)), length=22.996598mm)
  PML_Box2_26 [PMLGroup1_XYZ_7, oriented by FaceCS2] = sweep_along_normal(PML_Box2_13.face(at (20, 51.4983, -31.4983)), length=22.996598mm)
  Box3 [polyester] = box(corner=(-15mm, 0mm, 0mm), size=(30mm, 30mm, -0.2mm))
  [SMACore, SMASub, SMAGND, SMAport1, SMACylinder].rotate(axis=X, angle=90deg)
  [SMACore, SMASub, SMAGND, SMAport1, SMACylinder].move(0mm, 0mm, -1.6mm)
  SMACore1 = cylinder(axis=Y, base_centre=(0mm, 0mm, 0mm), radius=R_core, height=-SMA_length)
  SMACore1.move(0mm, -0.1mm, R_pin)
  SMAPin1 = cylinder(axis=Y, base_centre=(0mm, 0mm, 0mm), radius=R_pin, height=L_pin)
  SMAPin1.move(0mm, -0.1mm, R_pin)
  SMACore1.unite(SMAPin1)
  SMACore1.rotate(axis=X, angle=90deg)
  SMACore1.move(0mm, 0mm, -1.7mm)
  [SMACore, SMASub, SMAGND, SMAport1, SMACylinder, SMACore1].move(0mm, l_feed+l_slot, 0mm)
  Box1.subtract(SMACore1)
  SMACore2 = cylinder(axis=Y, base_centre=(0mm, 0mm, 0mm), radius=R_core, height=-SMA_length)
  SMACore2.move(0mm, -0.1mm, R_pin)
  SMAPin2 = cylinder(axis=Y, base_centre=(0mm, 0mm, 0mm), radius=R_pin, height=L_pin)
  SMAPin2.move(0mm, -0.1mm, R_pin)
  SMACore2.unite(SMAPin2)
  SMACore2.rotate(axis=X, angle=90deg)
  SMACore2.move(0mm, 0mm, -1.7mm)
  SMACore2.move(0mm, l_feed+l_slot, 0mm)
  Box3.subtract(SMACore2)
  SMAGND1 = cylinder(axis=Y, base_centre=(0mm, 0mm, 0mm), radius=2.5mm, height=-SMA_length)
  Cylinder6 = cylinder(axis=Y, base_centre=(0mm, 0mm, 0mm), radius=4mm, height=-1mm)
  SMAGND1.unite(Cylinder6)
  SMASub1 = cylinder(axis=Y, base_centre=(0mm, 0mm, 0mm), radius=R_out, height=-SMA_length)
  Sub_2 = SMASub1.copy()
  SMAGND1.subtract(Sub_2)
  SMASub1.delete()
  SMAGND1.move(0mm, -0.1mm, R_pin)
  SMAGND1.rotate(axis=X, angle=90deg)
  SMAGND1.move(0mm, 0mm, -1.6mm)
  SMAGND1.move(0mm, l_feed+l_slot, 0mm)
  Box1.subtract(SMAGND1)
  SMASub2 = cylinder(axis=Y, base_centre=(0mm, 0mm, 0mm), radius=R_out, height=-SMA_length)
  SMACore3 = cylinder(axis=Y, base_centre=(0mm, 0mm, 0mm), radius=R_core, height=-SMA_length)
  Core_2 = SMACore3.copy()
  SMASub2.subtract(Core_2)
  [SMASub2, SMACore3].move(0mm, -0.1mm, R_pin)
  SMAPin3 = cylinder(axis=Y, base_centre=(0mm, 0mm, 0mm), radius=R_pin, height=L_pin)
  SMAPin3.move(0mm, -0.1mm, R_pin)
  SMACore3.unite(SMAPin3)
  SMACore_2 = SMACore3.copy()
  SMASub2.subtract(SMACore_2)
  SMACore3.delete()
  SMASub2.rotate(axis=X, angle=90deg)
  SMASub2.move(0mm, 0mm, -1.6mm)
  SMASub2.move(0mm, l_feed+l_slot, 0mm)
  Box1.subtract(SMASub2)
  SMACore4 = cylinder(axis=Y, base_centre=(0mm, 0mm, 0mm), radius=R_core, height=-SMA_length)
  SMACore4.move(0mm, -0.1mm, R_pin)
  SMAPin4 = cylinder(axis=Y, base_centre=(0mm, 0mm, 0mm), radius=R_pin, height=L_pin)
  SMAPin4.move(0mm, -0.1mm, R_pin)
  SMACore4.unite(SMAPin4)
  SMACore4.rotate(axis=X, angle=90deg)
  SMACore4.move(0mm, 0mm, -1.6mm)
  SMACore4.move(0mm, l_feed+l_slot, 0mm)
  Box1.subtract(SMACore4)
  SMACore5 = cylinder(axis=Y, base_centre=(0mm, 0mm, 0mm), radius=R_core, height=-SMA_length)
  SMACore5.move(0mm, -0.1mm, R_pin)
  SMAPin5 = cylinder(axis=Y, base_centre=(0mm, 0mm, 0mm), radius=R_pin, height=L_pin)
  SMAPin5.move(0mm, -0.1mm, R_pin)
  SMACore5.unite(SMAPin5)
  SMACore5.rotate(axis=X, angle=90deg)
  SMACore5.move(0mm, 0mm, -1.6mm)
  SMACore5.move(0mm, l_feed+l_slot, 0mm)
  SMASub3 = cylinder(axis=Y, base_centre=(0mm, 0mm, 0mm), radius=R_out, height=-SMA_length)
  SMACore6 = cylinder(axis=Y, base_centre=(0mm, 0mm, 0mm), radius=R_core, height=-SMA_length)
  Core_3 = SMACore6.copy()
  SMASub3.subtract(Core_3)
  [SMASub3, SMACore6].move(0mm, -0.1mm, R_pin)
  SMAPin6 = cylinder(axis=Y, base_centre=(0mm, 0mm, 0mm), radius=R_pin, height=L_pin)
  SMAPin6.move(0mm, -0.1mm, R_pin)
  SMACore6.unite(SMAPin6)
  SMACore_3 = SMACore6.copy()
  SMASub3.subtract(SMACore_3)
  SMACore6.delete()
  SMASub3.rotate(axis=X, angle=90deg)
  SMASub3.move(0mm, 0mm, -1.6mm)
  SMASub3.move(0mm, l_feed+l_slot, 0mm)
  Rectangle4.subtract(SMACore5, SMASub3)
  SMACore7 [copper] = cylinder(axis=Y, base_centre=(0mm, 0mm, 0mm), radius=R_core, height=-SMA_length)
  Core_4 = SMACore7.copy()
  SMACore7.move(0mm, -0.1mm, R_pin)
  SMAPin7 = cylinder(axis=Y, base_centre=(0mm, 0mm, 0mm), radius=R_pin, height=L_pin)
  SMAPin7.move(0mm, -0.1mm, R_pin)
  SMACore7.unite(SMAPin7)
  SMACore_4 = SMACore7.copy()
  SMACore7.rotate(axis=X, angle=90deg)
  SMACore7.move(0mm, 0mm, -1.6mm)
  SMACore7.move(0mm, l_feed+l_slot, 0mm)
  SMASub4 [Teflon (tm)] = cylinder(axis=Y, base_centre=(0mm, 0mm, 0mm), radius=R_out, height=-SMA_length)
  Sub_3 = SMASub4.copy()
  SMASub4.subtract(Core_4)
  SMASub4.move(0mm, -0.1mm, R_pin)
  SMASub4.subtract(SMACore_4)
  SMASub4.rotate(axis=X, angle=90deg)
  SMASub4.move(0mm, 0mm, -1.6mm)
  SMASub4.move(0mm, l_feed+l_slot, 0mm)
  SMAGND2 [brass] = cylinder(axis=Y, base_centre=(0mm, 0mm, 0mm), radius=2.5mm, height=-SMA_length)
  Cylinder7 = cylinder(axis=Y, base_centre=(0mm, 0mm, 0mm), radius=4mm, height=-1mm)
  SMAGND2.unite(Cylinder7)
  SMAGND2.subtract(Sub_3)
  SMAGND2.move(0mm, -0.1mm, R_pin)
  SMAGND2.rotate(axis=X, angle=90deg)
  SMAGND2.move(0mm, 0mm, -1.6mm)
  SMAGND2.move(0mm, l_feed+l_slot, 0mm)
  SMAport2 = circle(normal=Y, centre=(0mm, -SMA_length, 0mm), radius=R_out)
  Circle2 = circle(normal=Y, centre=(0mm, -7.62mm, 0mm), radius=R_core)
  SMAport2.subtract(Circle2)
  SMAport2.move(0mm, -0.1mm, R_pin)
  SMAport2.rotate(axis=X, angle=90deg)
  SMAport2.move(0mm, 0mm, -1.6mm)
  SMAport2.move(0mm, l_feed+l_slot, 0mm)
  SMACylinder1 [pec] = cylinder(axis=Y, base_centre=(0mm, -SMA_length, 0mm), radius=2.5mm, height=-3mm)
  SMACylinder1.move(0mm, -0.1mm, R_pin)
  SMACylinder1.rotate(axis=X, angle=90deg)
  SMACylinder1.move(0mm, 0mm, -1.6mm)
  SMACylinder1.move(0mm, l_feed+l_slot, 0mm)
  group SMA_Group = SMACore, SMASub, SMAGND, SMAport1, SMACylinder
  group SMA_Group1 = SMACore7, SMASub4, SMAGND2, SMAport2, SMACylinder1
boundaries and excitations:
  FiniteCond1: Finite Conductivity Objects=Rectangle4 Conductivity=58000000 Permeability=1 Thickness=35um Roughness=1um IsInternal
  FiniteCond2: Finite Conductivity Objects=Rectangle2 Conductivity=cond Permeability=1 Thickness=t Roughness=rough IsInternal
  PML_radiation1: Radiation Faces=Box2.face(+z) IsForPML
  PML_radiation2: Radiation Faces=Box2.face(-z) IsForPML
  PML_radiation3: Radiation Faces=Box2.face(-y) IsForPML
  PML_radiation4: Radiation Faces=Box2.face(-x) IsForPML
  PML_radiation5: Radiation Faces=Box2.face(+y) IsForPML
  PML_radiation6: Radiation Faces=Box2.face(+x) IsForPML
  1: Wave Port Objects=SMAport1 NumModes=1 Modes{Mode1{CharImp=Zpi}}
setups:
  Setup1: HfssDriven Frequency=5GHz MaxDeltaS=0.02 MaximumPasses=20 MinimumPasses=1 MinimumConvergedPasses=1 PercentRefinement=30 BasisOrder=1 PortAccuracy=2
    sweep Sweep: 4GHz to 6GHz, 21 points; Type=Discrete SaveFields
source amplitudes:
  1:1: 1W 0deg
radiation setups:
  Infinite Sphere1: Infinite Sphere Theta=-180deg..180deg step 1deg Phi=-180deg..180deg step 1deg
field plots:
  Mag_E1: E Field over Rectangle2.face on Setup1 : LastAdaptive at Freq=5GHz Phase=0deg
reports:
  S Parameter Plot 1: dB(S(1,1)) vs Freq on Setup1 : Sweep; markers m1 at 13.9GHz
  S Parameter Chart 1: S(1,1) on Setup1 : Sweep [Freq=all gap=all l_slot=all quarter_wave=all]; markers m1 at 5.3GHz
  Gain Plot 1: dB(GainTotal) vs Phi, Theta on Setup1 : Sweep, Infinite Sphere1 [Freq=5GHz]
  Antenna Params Table 1: RadiationEfficiency vs Freq on Setup1 : LastAdaptive; RadiationEfficiency vs Freq on Setup1 : Sweep [Freq=4GHz,4.5GHz,5GHz,5.3GHz,5.6GHz,6GHz]
  Gain Plot 2: dB(GainTotal) vs Theta on Setup1 : Sweep, Infinite Sphere1 [Phi=90deg Freq=15.5GHz]; markers m1 at 2deg

design 10G_5880_62mil10G1 (HFSS, DrivenModal, model units mm)
variables:
  w = 11mm
  l = 8.1mm
  l_feed = 5mm
  w_feed = 1.2mm
  gap = 1mm
  l_slot = 1.8mm
  cond = 1000000
  rough = 0.1um
  t = 2um
  w50 = 38mil
  R_core = 10mil
  R_pin = 5mil
  L_pin = 50mil
  R_out = (63.5/2) mil
  w_taper = 1mm
  l_taper = 1.2mm
  th = 1.6mm
  SMA_length = 4.24mm
  quarter_wave = 2.5mm
  w_quarter_wave = 1.2mm
  w_taper2 = 0.5mm
geometry:
  Box1 [Rogers RT/duroid 5880 (tm)] = box(corner=(-15mm, 0mm, -0.2mm), size=(30mm, 30mm, -th))
  Rectangle1 = rectangle(corner=(-w_feed/2, 0mm, 0mm), x_size=w_feed, y_size=l_feed)
  Rectangle2 = rectangle(corner=(-w/2, l_feed, 0mm), x_size=w, y_size=l)
  Rectangle3 = rectangle(corner=(-w_feed/2, l_feed, 0mm), x_size=-gap, y_size=l_slot)
  Rectangle3_1 = Rectangle3.duplicate_mirror(point=(0mm, 0mm, 0mm), normal=(1mm, 0mm, 0mm))
  Rectangle2.subtract(Rectangle3, Rectangle3_1)
  Rectangle2.unite(Rectangle1)
  Rectangle4 = rectangle(corner=(15mm, -0.1mm, -th-0.2mm), x_size=-30mm, y_size=30mm)
  Box2 [vacuum] = box(corner=(-20mm, -20mm, -20mm), size=(40mm, 60mm, 40mm))
  coordinate_system FaceCS1 = face of Box2: Origin=Box2.vertex(1 of 8) FaceID=Box2.face(+z) AxisPosn=Box2.vertex(2 of 8) WhichAxis=X
  PML_Box2_1 [PMLGroup1_Z_8, oriented by FaceCS1] = sweep_along_normal(Box2.face(+z), length=22.996598mm)
  coordinate_system FaceCS2 = face of Box2: Origin=Box2.vertex(5 of 8) FaceID=Box2.face(-z) AxisPosn=Box2.vertex(6 of 8) WhichAxis=X
  PML_Box2_2 [PMLGroup1_Z_8, oriented by FaceCS2] = sweep_along_normal(Box2.face(-z), length=22.996598mm)
  coordinate_system FaceCS3 = face of Box2: Origin=Box2.vertex(4 of 8) FaceID=Box2.face(-y) AxisPosn=Box2.vertex(7 of 8) WhichAxis=X
  PML_Box2_3 [PMLGroup1_Z_8, oriented by FaceCS3] = sweep_along_normal(Box2.face(-y), length=22.996598mm)
  coordinate_system FaceCS4 = face of Box2: Origin=Box2.vertex(3 of 8) FaceID=Box2.face(-x) AxisPosn=Box2.vertex(8 of 8) WhichAxis=X
  PML_Box2_4 [PMLGroup1_Z_8, oriented by FaceCS4] = sweep_along_normal(Box2.face(-x), length=22.996598mm)
  coordinate_system FaceCS5 = face of Box2: Origin=Box2.vertex(2 of 8) FaceID=Box2.face(+y) AxisPosn=Box2.vertex(5 of 8) WhichAxis=X
  PML_Box2_5 [PMLGroup1_Z_8, oriented by FaceCS5] = sweep_along_normal(Box2.face(+y), length=22.996598mm)
  coordinate_system FaceCS6 = face of Box2: Origin=Box2.vertex(1 of 8) FaceID=Box2.face(+x) AxisPosn=Box2.vertex(6 of 8) WhichAxis=X
  PML_Box2_6 [PMLGroup1_Z_8, oriented by FaceCS6] = sweep_along_normal(Box2.face(+x), length=22.996598mm)
  PML_Box2_7 [PMLGroup1_XZ_8, oriented by FaceCS3] = sweep_along_normal(PML_Box2_1.face(at (0, -20, 31.4983)), length=22.996598mm)
  PML_Box2_8 [PMLGroup1_XZ_8, oriented by FaceCS4] = sweep_along_normal(PML_Box2_1.face(at (-20, 10, 31.4983)), length=22.996598mm)
  PML_Box2_9 [PMLGroup1_XZ_8, oriented by FaceCS5] = sweep_along_normal(PML_Box2_1.face(at (0, 40, 31.4983)), length=22.996598mm)
  PML_Box2_10 [PMLGroup1_YZ_8, oriented by FaceCS1] = sweep_along_normal(PML_Box2_1.face(at (20, 10, 31.4983)), length=22.996598mm)
  coordinate_system FaceCS7 = face of Box2: Origin=Box2.vertex(6 of 8) FaceID=Box2.face(-z) AxisPosn=Box2.vertex(7 of 8) WhichAxis=X
  PML_Box2_11 [PMLGroup1_YZ_8, oriented by FaceCS7] = sweep_along_normal(PML_Box2_2.face(at (0, -20, -31.4983)), length=22.996598mm)
  coordinate_system FaceCS8 = face of Box2: Origin=Box2.vertex(7 of 8) FaceID=Box2.face(-z) AxisPosn=Box2.vertex(8 of 8) WhichAxis=X
  PML_Box2_12 [PMLGroup1_YZ_8, oriented by FaceCS8] = sweep_along_normal(PML_Box2_2.face(at (-20, 10, -31.4983)), length=22.996598mm)
  PML_Box2_13 [PMLGroup1_XZ_8, oriented by FaceCS2] = sweep_along_normal(PML_Box2_2.face(at (0, 40, -31.4983)), length=22.996598mm)
  PML_Box2_14 [PMLGroup1_YZ_8, oriented by FaceCS2] = sweep_along_normal(PML_Box2_2.face(at (20, 10, -31.4983)), length=22.996598mm)
  PML_Box2_15 [PMLGroup1_YZ_8, oriented by FaceCS3] = sweep_along_normal(PML_Box2_3.face(at (-20, -31.4983, 0)), length=22.996598mm)
  PML_Box2_16 [PMLGroup1_YZ_8, oriented by FaceCS6] = sweep_along_normal(PML_Box2_3.face(at (20, -31.4983, 0)), length=22.996598mm)
  PML_Box2_17 [PMLGroup1_YZ_8, oriented by FaceCS4] = sweep_along_normal(PML_Box2_4.face(at (-31.4983, 40, 0)), length=22.996598mm)
  PML_Box2_18 [PMLGroup1_YZ_8, oriented by FaceCS5] = sweep_along_normal(PML_Box2_5.face(at (20, 51.4983, 0)), length=22.996598mm)
  PML_Box2_19 [PMLGroup1_XYZ_8, oriented by FaceCS3] = sweep_along_normal(PML_Box2_7.face(at (-20, -31.4983, 31.4983)), length=22.996598mm)
  PML_Box2_20 [PMLGroup1_XYZ_8, oriented by FaceCS1] = sweep_along_normal(PML_Box2_7.face(at (20, -31.4983, 31.4983)), length=22.996598mm)
  PML_Box2_21 [PMLGroup1_XYZ_8, oriented by FaceCS4] = sweep_along_normal(PML_Box2_8.face(at (-31.4983, 40, 31.4983)), length=22.996598mm)
  PML_Box2_22 [PMLGroup1_XYZ_8, oriented by FaceCS5] = sweep_along_normal(PML_Box2_9.face(at (20, 51.4983, 31.4983)), length=22.996598mm)
  PML_Box2_23 [PMLGroup1_XYZ_8, oriented by FaceCS8] = sweep_along_normal(PML_Box2_11.face(at (-20, -31.4983, -31.4983)), length=22.996598mm)
  PML_Box2_24 [PMLGroup1_XYZ_8, oriented by FaceCS7] = sweep_along_normal(PML_Box2_11.face(at (20, -31.4983, -31.4983)), length=22.996598mm)
  coordinate_system FaceCS9 = face of Box2: Origin=Box2.vertex(8 of 8) FaceID=Box2.face(-z) AxisPosn=Box2.vertex(5 of 8) WhichAxis=X
  PML_Box2_25 [PMLGroup1_XYZ_8, oriented by FaceCS9] = sweep_along_normal(PML_Box2_12.face(at (-31.4983, 40, -31.4983)), length=22.996598mm)
  PML_Box2_26 [PMLGroup1_XYZ_8, oriented by FaceCS2] = sweep_along_normal(PML_Box2_13.face(at (20, 51.4983, -31.4983)), length=22.996598mm)
  Box3 [polyester] = box(corner=(-15mm, 0mm, 0mm), size=(30mm, 30mm, -0.2mm))
  Polyline1 = polyline(z=0mm, xy: (w_taper, 0mm) (w_feed/2, l_taper) (w_feed/2, 0mm) (w_taper, 0mm), closed, covered)
  Polyline1_1 = Polyline1.duplicate_mirror(point=(0mm, 0mm, 0mm), normal=(-1mm, 0mm, 0mm))
  Rectangle2.subtract(Polyline1, Polyline1_1)
  Rectangle2.move(0mm, quarter_wave, 0mm)
  Rectangle5 = rectangle(corner=(-w_quarter_wave/2, 0mm, 0mm), x_size=w_quarter_wave, y_size=quarter_wave)
  Rectangle2.unite(Rectangle5)
  Polyline2 = polyline(z=0mm, xy: (w_taper2, 0mm) (w_quarter_wave/2, 0mm) (w_quarter_wave/2, 1.4mm) (w_taper2, 0mm), closed, covered)
  Polyline2_1 = Polyline2.duplicate_mirror(point=(0mm, 0mm, 0mm), normal=(-1mm, 0mm, 0mm))
  Rectangle2.subtract(Polyline2, Polyline2_1)
  SMACore [copper] = cylinder(axis=Y, base_centre=(0mm, 0mm, 0mm), radius=R_core, height=-SMA_length)
  Core_1 = SMACore.copy()
  SMACore.move(0mm, -0.1mm, R_pin)
  SMAPin = cylinder(axis=Y, base_centre=(0mm, 0mm, 0mm), radius=R_pin, height=L_pin)
  SMAPin.move(0mm, -0.1mm, R_pin)
  SMACore.unite(SMAPin)
  185mmcore = cylinder(axis=Y, base_centre=(0mm, -4.24mm, 0mm), radius=0.8mm/2, height=-10.15mm)
  185mmcore_1 = 185mmcore.copy()
  185mmcore_2 = 185mmcore.copy()
  185mmcore.move(0mm, -0.1mm, R_pin)
  SMACore.unite(185mmcore)
  SMASub [Teflon (tm)] = cylinder(axis=Y, base_centre=(0mm, 0mm, 0mm), radius=R_out, height=-SMA_length)
  SMASub.subtract(Core_1)
  SMASub.move(0mm, -0.1mm, R_pin)
  SMAGND [brass] = cylinder(axis=Y, base_centre=(0mm, 0mm, 0mm), radius=2.5mm, height=-SMA_length)
  Box5 = box(corner=(-12.7mm/2, 0mm, 4.81mm), size=(12.7mm, -4.24mm, -9.53mm))
  Box6 = box(corner=(-12.7mm/2, 0.5mm, 4.81mm), size=(12.7mm, -4.24mm-0.5mm, -4.81mm-R_pin))
  Box5.unite(Box6)
  SMAGND.unite(Box5)
  Cylinder1 = cylinder(axis=Y, base_centre=(0mm, 0.5mm, 0mm), radius=R_out, height=-SMA_length-0.5mm)
  SMAGND.subtract(Cylinder1)
  SMAGND.move(0mm, -0.1mm, R_pin)
  Box4 = box(corner=(6.35mm/2, -0.1mm, 0mm), size=(6.35mm/2, 9.32mm-4.24mm, 4.81mm))
  Box4_1 = Box4.duplicate_mirror(point=(0mm, 0mm, 0mm), normal=(1mm, 0mm, 0mm))
  SMAGND.unite(Box4, Box4_1)
  185mmGND = cylinder(axis=Y, base_centre=(0mm, -4.24mm, 0mm), radius=4mm, height=-10.15mm)
  185mmsub [vacuum] = cylinder(axis=Y, base_centre=(0mm, -4.24mm, 0mm), radius=1.85mm/2, height=-10.15mm)
  185mmsub_1 = 185mmsub.copy()
  185mmGND.subtract(185mmcore_1, 185mmsub_1)
  185mmGND.move(0mm, -0.1mm, R_pin)
  SMAGND.unite(185mmGND)
  SMACylinder [pec] = cylinder(axis=Y, base_centre=(0mm, -SMA_length, 0mm), radius=4mm, height=-3mm)
  SMACylinder.move(0mm, -0.1mm, R_pin)
  SMACylinder.move(0mm, -10.15mm, 0mm)
  185mmsub.subtract(185mmcore_2)
  185mmsub.move(0mm, -0.1mm, R_pin)
  port = circle(normal=Y, centre=(0mm, -4.24mm-10.15mm, 0mm), radius=1.85mm/2)
  Circle2 = circle(normal=Y, centre=(0mm, -4.24mm-10.15mm, 0mm), radius=0.4mm)
  port.subtract(Circle2)
  port.move(0mm, -0.1mm, R_pin)
  group 1_85mm = SMACore, SMASub, SMAGND, SMACylinder, 185mmsub, port
boundaries and excitations:
  FiniteCond1: Finite Conductivity Objects=Rectangle4 Conductivity=58000000 Permeability=1 Thickness=35um Roughness=1um IsInternal
  FiniteCond2: Finite Conductivity Objects=Rectangle2 Conductivity=cond Permeability=1 Thickness=t Roughness=rough IsInternal
  PML_radiation1: Radiation Faces=Box2.face(+z) IsForPML
  PML_radiation2: Radiation Faces=Box2.face(-z) IsForPML
  PML_radiation3: Radiation Faces=Box2.face(-y) IsForPML
  PML_radiation4: Radiation Faces=Box2.face(-x) IsForPML
  PML_radiation5: Radiation Faces=Box2.face(+y) IsForPML
  PML_radiation6: Radiation Faces=Box2.face(+x) IsForPML
  1: Wave Port Objects=port NumModes=1 Modes{Mode1{CharImp=Zpi}}
setups:
  Setup1: HfssDriven Frequency=10GHz MaxDeltaS=0.02 MaximumPasses=20 MinimumPasses=1 MinimumConvergedPasses=1 PercentRefinement=30 BasisOrder=1 PortAccuracy=2
    sweep Sweep: 9GHz to 11GHz, 21 points; Type=Discrete SaveFields
source amplitudes:
  1:1: 1W 0deg
radiation setups:
  Infinite Sphere1: Infinite Sphere Theta=-180deg..180deg step 1deg Phi=-180deg..180deg step 1deg
field plots:
  Mag_E1: E Field over Rectangle2.face(#68) on Setup1 : LastAdaptive at Freq=10GHz Phase=0deg
reports:
  S Parameter Plot 1: dB(S(1,1)) vs Freq on Setup1 : Sweep; markers m1 at 13.9GHz
  S Parameter Chart 1: S(1,1) on Setup1 : Sweep [Freq=all]; markers m1 at 10GHz
  Gain Plot 1: dB(GainTotal) vs Phi, Theta on Setup1 : Sweep, Infinite Sphere1 [Freq=15.3GHz]
  Antenna Params Table 1: RadiationEfficiency vs Freq on Setup1 : LastAdaptive; RadiationEfficiency vs Freq on Setup1 : Sweep [Freq=9GHz,9.5GHz,10GHz,10.5GHz,11GHz]
  VSWR Plot 1: VSWR(1) vs Freq on Setup1 : Sweep
  Gain Plot 2: dB(GainTotal) vs Theta on Setup1 : Sweep, Infinite Sphere1 [Phi=0deg,90deg Freq=10GHz]; markers m1 at 48deg
